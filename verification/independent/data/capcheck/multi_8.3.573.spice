* NGSPICE file created from multi.ext - technology: gf180mcuD

.option scale=5n

C0 X W4 0.08843f
C1 W1 X 0.13897f
C2 W2 X 0.08843f
C3 W1 W2 8.81811f
C4 W3 X 0.08843f
C5 W3 W4 8.81811f
C6 W2 W3 8.81811f
C7 W5 X 0.13964f
C8 W5 W4 8.81811f
C9 X VSUBS 1.08042f
C10 W1 VSUBS 3.94673f
C11 W2 VSUBS 0.79476f
C12 W3 VSUBS 0.79476f
C13 W4 VSUBS 0.79476f
C14 W5 VSUBS 3.94673f
