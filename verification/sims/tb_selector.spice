** sch_path: ~/ece298a/round2/benches/tb_selector.sch
**.subckt tb_selector
vvdd VDD GND 3.3
vs0 cfg_0 GND PWL(0 0 10n 0 10.1n 3.3 20n 3.3 20.1n 0 30n 0 30.1n 3.3)
vs1 cfg_1 GND PWL(0 0 20n 0 20.1n 3.3)
xsel cfg_0 cfg_1 VDD 0 VDD 0 selected_q selector
**** begin user architecture code

.include /usr/local/share/pdk/gf180mcuD/libs.tech/ngspice/design.ngspice
.lib /usr/local/share/pdk/gf180mcuD/libs.tech/ngspice/sm141064.ngspice typical
.lib /usr/local/share/pdk/gf180mcuD/libs.tech/ngspice/sm141064.ngspice diode_typical
.global VDD
.param sw_stat_global=0 sw_stat_mismatch=0
.control
set filetype=ascii
tran 10p 40n
meas tran s0 find v(selected_q) at=9n
echo RESULT sel0_V $&s0
meas tran s1 find v(selected_q) at=19n
echo RESULT sel1_V $&s1
meas tran s2 find v(selected_q) at=29n
echo RESULT sel2_V $&s2
meas tran s3 find v(selected_q) at=39n
echo RESULT sel3_V $&s3
wrdata tb_selector.dat v(cfg_0) v(cfg_1) v(selected_q)
.endc

**** end user architecture code
**.ends

* expanding   symbol:  ~/ece298a/round2/blocks/selector.sym # of pins=7
** sym_path: ~/ece298a/round2/blocks/selector.sym
** sch_path: ~/ece298a/round2/blocks/selector.sch
.subckt selector cfg_0 cfg_1 q_0 q_1 q_2 q_3 selected_q
*.ipin cfg_0
*.ipin cfg_1
*.ipin q_0
*.ipin q_1
*.ipin q_2
*.ipin q_3
*.opin selected_q
xselect_dut q_0 q_1 q_2 q_3 cfg_0 cfg_1 selected_q mux4_1
.ends

* expanding   symbol:  ~/ece298a/round2/cells_tx/mux4_1.sym # of pins=7
** sym_path: ~/ece298a/round2/cells_tx/mux4_1.sym
** sch_path: ~/ece298a/round2/cells_tx/mux4_1.sch
.subckt mux4_1 I0 I1 I2 I3 S0 S1 Z
*.ipin I0
*.ipin I1
*.ipin I2
*.ipin I3
*.ipin S0
*.ipin S1
*.opin Z
XM_MN5 net6 I2 0 0 nfet_05v0 L=0.6u W=0.365u nf=1 ad=1.825e-13 as=1.825e-13 pd=1.73e-06 ps=1.73e-06
+ nrd=0 nrs=0 sa=0 sb=0 sd=0 m=1
XM_MN9 net3 net1 net6 0 nfet_05v0 L=0.6u W=0.365u nf=1 ad=1.825e-13 as=1.825e-13 pd=1.73e-06
+ ps=1.73e-06 nrd=0 nrs=0 sa=0 sb=0 sd=0 m=1
XM_MN10 net3 S0 net7 0 nfet_05v0 L=0.6u W=0.365u nf=1 ad=1.825e-13 as=1.825e-13 pd=1.73e-06
+ ps=1.73e-06 nrd=0 nrs=0 sa=0 sb=0 sd=0 m=1
XM_MN6 net7 I3 0 0 nfet_05v0 L=0.6u W=0.365u nf=1 ad=1.825e-13 as=1.825e-13 pd=1.73e-06 ps=1.73e-06
+ nrd=0 nrs=0 sa=0 sb=0 sd=0 m=1
XM_instance_22 Z net2 0 0 nfet_05v0 L=0.6u W=0.38u nf=1 ad=1.9e-13 as=1.9e-13 pd=1.76e-06
+ ps=1.76e-06 nrd=0 nrs=0 sa=0 sb=0 sd=0 m=1
XM_MN12 net2 S1 net3 0 nfet_05v0 L=0.6u W=0.365u nf=1 ad=1.825e-13 as=1.825e-13 pd=1.73e-06
+ ps=1.73e-06 nrd=0 nrs=0 sa=0 sb=0 sd=0 m=1
XM_MN11 net2 net5 net4 0 nfet_05v0 L=0.6u W=0.365u nf=1 ad=1.825e-13 as=1.825e-13 pd=1.73e-06
+ ps=1.73e-06 nrd=0 nrs=0 sa=0 sb=0 sd=0 m=1
XM_MN2 net5 S1 0 0 nfet_05v0 L=0.6u W=0.365u nf=1 ad=1.825e-13 as=1.825e-13 pd=1.73e-06 ps=1.73e-06
+ nrd=0 nrs=0 sa=0 sb=0 sd=0 m=1
XM_MN4 net8 I1 0 0 nfet_05v0 L=0.6u W=0.365u nf=1 ad=1.825e-13 as=1.825e-13 pd=1.73e-06 ps=1.73e-06
+ nrd=0 nrs=0 sa=0 sb=0 sd=0 m=1
XM_MN8 net4 S0 net8 0 nfet_05v0 L=0.6u W=0.365u nf=1 ad=1.825e-13 as=1.825e-13 pd=1.73e-06
+ ps=1.73e-06 nrd=0 nrs=0 sa=0 sb=0 sd=0 m=1
XM_MN7 net4 net1 net9 0 nfet_05v0 L=0.6u W=0.365u nf=1 ad=1.825e-13 as=1.825e-13 pd=1.73e-06
+ ps=1.73e-06 nrd=0 nrs=0 sa=0 sb=0 sd=0 m=1
XM_MN3 net9 I0 0 0 nfet_05v0 L=0.6u W=0.365u nf=1 ad=1.825e-13 as=1.825e-13 pd=1.73e-06 ps=1.73e-06
+ nrd=0 nrs=0 sa=0 sb=0 sd=0 m=1
XM_MN1 net1 S0 0 0 nfet_05v0 L=0.6u W=0.365u nf=1 ad=1.825e-13 as=1.825e-13 pd=1.73e-06 ps=1.73e-06
+ nrd=0 nrs=0 sa=0 sb=0 sd=0 m=1
XM_MP2 net6 I2 VDD VDD pfet_05v0 L=0.5u W=0.565u nf=1 ad=2.825e-13 as=2.825e-13 pd=2.13e-06
+ ps=2.13e-06 nrd=0 nrs=0 sa=0 sb=0 sd=0 m=1
XM_MP9 net3 S0 net6 VDD pfet_05v0 L=0.5u W=0.565u nf=1 ad=2.825e-13 as=2.825e-13 pd=2.13e-06
+ ps=2.13e-06 nrd=0 nrs=0 sa=0 sb=0 sd=0 m=1
XM_MP10 net3 net1 net7 VDD pfet_05v0 L=0.5u W=0.565u nf=1 ad=2.825e-13 as=2.825e-13 pd=2.13e-06
+ ps=2.13e-06 nrd=0 nrs=0 sa=0 sb=0 sd=0 m=1
XM_MP6 net7 I3 VDD VDD pfet_05v0 L=0.5u W=0.565u nf=1 ad=2.825e-13 as=2.825e-13 pd=2.13e-06
+ ps=2.13e-06 nrd=0 nrs=0 sa=0 sb=0 sd=0 m=1
XM_instance_1 Z net2 VDD VDD pfet_05v0 L=0.5u W=0.78u nf=1 ad=3.9e-13 as=3.9e-13 pd=2.56e-06
+ ps=2.56e-06 nrd=0 nrs=0 sa=0 sb=0 sd=0 m=1
XM_MP12 net2 net5 net3 VDD pfet_05v0 L=0.5u W=0.565u nf=1 ad=2.825e-13 as=2.825e-13 pd=2.13e-06
+ ps=2.13e-06 nrd=0 nrs=0 sa=0 sb=0 sd=0 m=1
XM_MP11 net2 S1 net4 VDD pfet_05v0 L=0.5u W=0.565u nf=1 ad=2.825e-13 as=2.825e-13 pd=2.13e-06
+ ps=2.13e-06 nrd=0 nrs=0 sa=0 sb=0 sd=0 m=1
XM_MP5 net5 S1 VDD VDD pfet_05v0 L=0.5u W=0.565u nf=1 ad=2.825e-13 as=2.825e-13 pd=2.13e-06
+ ps=2.13e-06 nrd=0 nrs=0 sa=0 sb=0 sd=0 m=1
XM_MP4 net8 I1 VDD VDD pfet_05v0 L=0.5u W=0.565u nf=1 ad=2.825e-13 as=2.825e-13 pd=2.13e-06
+ ps=2.13e-06 nrd=0 nrs=0 sa=0 sb=0 sd=0 m=1
XM_MP8 net4 net1 net8 VDD pfet_05v0 L=0.5u W=0.565u nf=1 ad=2.825e-13 as=2.825e-13 pd=2.13e-06
+ ps=2.13e-06 nrd=0 nrs=0 sa=0 sb=0 sd=0 m=1
XM_MP7 net4 S0 net9 VDD pfet_05v0 L=0.5u W=0.565u nf=1 ad=2.825e-13 as=2.825e-13 pd=2.13e-06
+ ps=2.13e-06 nrd=0 nrs=0 sa=0 sb=0 sd=0 m=1
XM_MP3 net9 I0 VDD VDD pfet_05v0 L=0.5u W=0.565u nf=1 ad=2.825e-13 as=2.825e-13 pd=2.13e-06
+ ps=2.13e-06 nrd=0 nrs=0 sa=0 sb=0 sd=0 m=1
XM_MP1 net1 S0 VDD VDD pfet_05v0 L=0.5u W=0.565u nf=1 ad=2.825e-13 as=2.825e-13 pd=2.13e-06
+ ps=2.13e-06 nrd=0 nrs=0 sa=0 sb=0 sd=0 m=1
.ends

.GLOBAL GND
.GLOBAL VDD
.end
