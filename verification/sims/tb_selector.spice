** sch_path: ~/metastability-298/build/sims/kit/benches/tb_selector.sch
**.subckt tb_selector
vvdd VDD GND 3.3
vs0 ui_in_3 GND PWL(0 0 10n 0 10.1n 3.3 20n 3.3 20.1n 0 30n 0 30.1n 3.3)
vs1 uio_in_6 GND PWL(0 0 20n 0 20.1n 3.3)
xsel VDD 0 VDD 0 ui_in_3 uio_in_6 selected_q selector
**** begin user architecture code

.include ~/.ciel/ciel/gf180mcu/versions/e8daeda73ca8f5814dbc0b11d1d05802251a3750/gf180mcuD/libs.tech/ngspice/design.ngspice
.lib ~/.ciel/ciel/gf180mcu/versions/e8daeda73ca8f5814dbc0b11d1d05802251a3750/gf180mcuD/libs.tech/ngspice/sm141064.ngspice typical
.lib ~/.ciel/ciel/gf180mcu/versions/e8daeda73ca8f5814dbc0b11d1d05802251a3750/gf180mcuD/libs.tech/ngspice/sm141064.ngspice diode_typical
.global VDD
.param sw_stat_global=0 sw_stat_mismatch=0
.control
set filetype=ascii
tran 10p 40n
meas tran s0 find v(selected_q) at=9n
echo RESULT sel0_V $&s0
meas tran s1 find v(selected_q) at=19n
echo RESULT sel1_V $&s1
meas tran s2 find v(selected_q) at=29n
echo RESULT sel2_V $&s2
meas tran s3 find v(selected_q) at=39n
echo RESULT sel3_V $&s3
wrdata tb_selector.dat v(ui_in_3) v(uio_in_6) v(selected_q)
.endc

**** end user architecture code
**.ends

* expanding   symbol:  ~/metastability-298/build/sims/kit/blocks/selector.sym # of pins=7
** sym_path: ~/metastability-298/build/sims/kit/blocks/selector.sym
** sch_path: ~/metastability-298/build/sims/kit/blocks/selector.sch
.subckt selector q_0 q_1 q_2 q_3 ui_in_3 uio_in_6 selected_q
*.ipin q_0
*.ipin q_1
*.ipin q_2
*.ipin q_3
*.ipin ui_in_3
*.ipin uio_in_6
*.opin selected_q
xselect_dut q_0 q_1 q_2 q_3 ui_in_3 uio_in_6 selected_q mux4_1
.ends

* expanding   symbol:  ~/metastability-298/build/sims/kit/cells_tx/mux4_1.sym # of pins=7
** sym_path: ~/metastability-298/build/sims/kit/cells_tx/mux4_1.sym
** sch_path: ~/metastability-298/build/sims/kit/cells_tx/mux4_1.sch
.subckt mux4_1 I0 I1 I2 I3 S0 S1 Z
*.ipin I0
*.ipin I1
*.ipin I2
*.ipin I3
*.ipin S0
*.ipin S1
*.opin Z
XM_MN5 net6 I2 0 0 nfet_05v0 L=0.6u W=0.365u nf=1 ad=1.825e-13 as=1.825e-13 pd=1.73e-06 ps=1.73e-06
+ nrd=0 nrs=0 sa=0 sb=0 sd=0 m=1
XM_MN9 net3 net1 net6 0 nfet_05v0 L=0.6u W=0.365u nf=1 ad=1.825e-13 as=1.825e-13 pd=1.73e-06
+ ps=1.73e-06 nrd=0 nrs=0 sa=0 sb=0 sd=0 m=1
XM_MN10 net3 S0 net7 0 nfet_05v0 L=0.6u W=0.365u nf=1 ad=1.825e-13 as=1.825e-13 pd=1.73e-06
+ ps=1.73e-06 nrd=0 nrs=0 sa=0 sb=0 sd=0 m=1
XM_MN6 net7 I3 0 0 nfet_05v0 L=0.6u W=0.365u nf=1 ad=1.825e-13 as=1.825e-13 pd=1.73e-06 ps=1.73e-06
+ nrd=0 nrs=0 sa=0 sb=0 sd=0 m=1
XM_instance_22 Z net2 0 0 nfet_05v0 L=0.6u W=0.38u nf=1 ad=1.9e-13 as=1.9e-13 pd=1.76e-06
+ ps=1.76e-06 nrd=0 nrs=0 sa=0 sb=0 sd=0 m=1
XM_MN12 net2 S1 net3 0 nfet_05v0 L=0.6u W=0.365u nf=1 ad=1.825e-13 as=1.825e-13 pd=1.73e-06
+ ps=1.73e-06 nrd=0 nrs=0 sa=0 sb=0 sd=0 m=1
XM_MN11 net2 net5 net4 0 nfet_05v0 L=0.6u W=0.365u nf=1 ad=1.825e-13 as=1.825e-13 pd=1.73e-06
+ ps=1.73e-06 nrd=0 nrs=0 sa=0 sb=0 sd=0 m=1
XM_MN2 net5 S1 0 0 nfet_05v0 L=0.6u W=0.365u nf=1 ad=1.825e-13 as=1.825e-13 pd=1.73e-06 ps=1.73e-06
+ nrd=0 nrs=0 sa=0 sb=0 sd=0 m=1
XM_MN4 net8 I1 0 0 nfet_05v0 L=0.6u W=0.365u nf=1 ad=1.825e-13 as=1.825e-13 pd=1.73e-06 ps=1.73e-06
+ nrd=0 nrs=0 sa=0 sb=0 sd=0 m=1
XM_MN8 net4 S0 net8 0 nfet_05v0 L=0.6u W=0.365u nf=1 ad=1.825e-13 as=1.825e-13 pd=1.73e-06
+ ps=1.73e-06 nrd=0 nrs=0 sa=0 sb=0 sd=0 m=1
XM_MN7 net4 net1 net9 0 nfet_05v0 L=0.6u W=0.365u nf=1 ad=1.825e-13 as=1.825e-13 pd=1.73e-06
+ ps=1.73e-06 nrd=0 nrs=0 sa=0 sb=0 sd=0 m=1
XM_MN3 net9 I0 0 0 nfet_05v0 L=0.6u W=0.365u nf=1 ad=1.825e-13 as=1.825e-13 pd=1.73e-06 ps=1.73e-06
+ nrd=0 nrs=0 sa=0 sb=0 sd=0 m=1
XM_MN1 net1 S0 0 0 nfet_05v0 L=0.6u W=0.365u nf=1 ad=1.825e-13 as=1.825e-13 pd=1.73e-06 ps=1.73e-06
+ nrd=0 nrs=0 sa=0 sb=0 sd=0 m=1
XM_MP2 net6 I2 VDD VDD pfet_05v0 L=0.5u W=0.565u nf=1 ad=2.825e-13 as=2.825e-13 pd=2.13e-06
+ ps=2.13e-06 nrd=0 nrs=0 sa=0 sb=0 sd=0 m=1
XM_MP9 net3 S0 net6 VDD pfet_05v0 L=0.5u W=0.565u nf=1 ad=2.825e-13 as=2.825e-13 pd=2.13e-06
+ ps=2.13e-06 nrd=0 nrs=0 sa=0 sb=0 sd=0 m=1
XM_MP10 net3 net1 net7 VDD pfet_05v0 L=0.5u W=0.565u nf=1 ad=2.825e-13 as=2.825e-13 pd=2.13e-06
+ ps=2.13e-06 nrd=0 nrs=0 sa=0 sb=0 sd=0 m=1
XM_MP6 net7 I3 VDD VDD pfet_05v0 L=0.5u W=0.565u nf=1 ad=2.825e-13 as=2.825e-13 pd=2.13e-06
+ ps=2.13e-06 nrd=0 nrs=0 sa=0 sb=0 sd=0 m=1
XM_instance_1 Z net2 VDD VDD pfet_05v0 L=0.5u W=0.78u nf=1 ad=3.9e-13 as=3.9e-13 pd=2.56e-06
+ ps=2.56e-06 nrd=0 nrs=0 sa=0 sb=0 sd=0 m=1
XM_MP12 net2 net5 net3 VDD pfet_05v0 L=0.5u W=0.565u nf=1 ad=2.825e-13 as=2.825e-13 pd=2.13e-06
+ ps=2.13e-06 nrd=0 nrs=0 sa=0 sb=0 sd=0 m=1
XM_MP11 net2 S1 net4 VDD pfet_05v0 L=0.5u W=0.565u nf=1 ad=2.825e-13 as=2.825e-13 pd=2.13e-06
+ ps=2.13e-06 nrd=0 nrs=0 sa=0 sb=0 sd=0 m=1
XM_MP5 net5 S1 VDD VDD pfet_05v0 L=0.5u W=0.565u nf=1 ad=2.825e-13 as=2.825e-13 pd=2.13e-06
+ ps=2.13e-06 nrd=0 nrs=0 sa=0 sb=0 sd=0 m=1
XM_MP4 net8 I1 VDD VDD pfet_05v0 L=0.5u W=0.565u nf=1 ad=2.825e-13 as=2.825e-13 pd=2.13e-06
+ ps=2.13e-06 nrd=0 nrs=0 sa=0 sb=0 sd=0 m=1
XM_MP8 net4 net1 net8 VDD pfet_05v0 L=0.5u W=0.565u nf=1 ad=2.825e-13 as=2.825e-13 pd=2.13e-06
+ ps=2.13e-06 nrd=0 nrs=0 sa=0 sb=0 sd=0 m=1
XM_MP7 net4 S0 net9 VDD pfet_05v0 L=0.5u W=0.565u nf=1 ad=2.825e-13 as=2.825e-13 pd=2.13e-06
+ ps=2.13e-06 nrd=0 nrs=0 sa=0 sb=0 sd=0 m=1
XM_MP3 net9 I0 VDD VDD pfet_05v0 L=0.5u W=0.565u nf=1 ad=2.825e-13 as=2.825e-13 pd=2.13e-06
+ ps=2.13e-06 nrd=0 nrs=0 sa=0 sb=0 sd=0 m=1
XM_MP1 net1 S0 VDD VDD pfet_05v0 L=0.5u W=0.565u nf=1 ad=2.825e-13 as=2.825e-13 pd=2.13e-06
+ ps=2.13e-06 nrd=0 nrs=0 sa=0 sb=0 sd=0 m=1
.ends

.GLOBAL GND
.GLOBAL VDD
.end
