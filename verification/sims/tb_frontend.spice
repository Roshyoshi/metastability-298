** sch_path: ~/metastability-298/build/sims/kit/benches/tb_frontend.sch
**.subckt tb_frontend
vvdd VDD GND 3.3
vcap capture GND PWL(0 0 1n 0 1.05n 3.3 2n 3.3 2.05n 0 5n 0 5.05n 3.3)
vd ui_in_6 GND PWL(0 0 2.975n 0 3.025n 3.3)
vs0 ui_in_3 GND 3.3
vs1 uio_in_6 GND 0
vbias ua_0 GND 3.0
xdata_input ui_in_6 data_local data_input
xcapture_drivers capture capture_local capture_drivers
xduts capture_local data_local q_0 q_1 q_2 q_3 duts
xselector q_0 q_1 q_2 q_3 ui_in_3 uio_in_6 selected_q selector
xdelay capture_local ua_0 early_clk delay
xearly_observer early_clk selected_q early_q early_observer
xmonitors capture_local early_clk uio_out_4 uio_out_5 monitors
**** begin user architecture code

.include ~/.ciel/ciel/gf180mcu/versions/e8daeda73ca8f5814dbc0b11d1d05802251a3750/gf180mcuD/libs.tech/ngspice/design.ngspice
.lib ~/.ciel/ciel/gf180mcu/versions/e8daeda73ca8f5814dbc0b11d1d05802251a3750/gf180mcuD/libs.tech/ngspice/sm141064.ngspice typical
.lib ~/.ciel/ciel/gf180mcu/versions/e8daeda73ca8f5814dbc0b11d1d05802251a3750/gf180mcuD/libs.tech/ngspice/sm141064.ngspice diode_typical
.global VDD
.param sw_stat_global=0 sw_stat_mismatch=0
.control
set filetype=ascii
tran 2p 14n
meas tran d_short trig v(capture_local) val=1.65 td=4n rise=1 targ v(early_clk) val=1.65 td=4n
+ rise=1
meas tran arrive trig v(capture_local) val=1.65 td=4n rise=1 targ v(selected_q) val=1.65 td=4n
+ rise=1
meas tran early_short find v(early_q) at=13.9n
meas tran final_short find v(selected_q) at=13.9n
wrdata tb_frontend_short.dat v(capture_local) v(selected_q) v(early_clk) v(early_q)
let a=d_short*1e12
echo RESULT d_short_ps $&a
let a=arrive*1e12
echo RESULT arrive_ps $&a
echo RESULT early_short_V $&early_short
echo RESULT final_short_V $&final_short
alter vbias 1.41171875
tran 2p 14n
meas tran d_allowed trig v(capture_local) val=1.65 td=4n rise=1 targ v(early_clk) val=1.65 td=4n
+ rise=1
meas tran early_allowed find v(early_q) at=13.9n
meas tran final_allowed find v(selected_q) at=13.9n
wrdata tb_frontend_allowed.dat v(capture_local) v(selected_q) v(early_clk) v(early_q)
let a=d_allowed*1e12
echo RESULT d_allowed_ps $&a
echo RESULT early_allowed_V $&early_allowed
echo RESULT final_allowed_V $&final_allowed
.endc

**** end user architecture code
**.ends

* expanding   symbol:  ~/metastability-298/build/sims/kit/blocks/data_input.sym # of
*+ pins=2
** sym_path: ~/metastability-298/build/sims/kit/blocks/data_input.sym
** sch_path: ~/metastability-298/build/sims/kit/blocks/data_input.sch
.subckt data_input ui_in_6 data_local
*.ipin ui_in_6
*.opin data_local
xdata0 ui_in_6 data_b inv_2
xdata1 data_b data_local inv_2
.ends

* expanding   symbol:  ~/metastability-298/build/sims/kit/blocks/capture_drivers.sym # of
*+ pins=2
** sym_path: ~/metastability-298/build/sims/kit/blocks/capture_drivers.sym
** sch_path: ~/metastability-298/build/sims/kit/blocks/capture_drivers.sch
.subckt capture_drivers capture capture_local
*.ipin capture
*.opin capture_local
xcap0 capture capture_b inv_2
xcap1 capture_b capture_local inv_2
.ends

* expanding   symbol:  ~/metastability-298/build/sims/kit/blocks/duts.sym # of pins=6
** sym_path: ~/metastability-298/build/sims/kit/blocks/duts.sym
** sch_path: ~/metastability-298/build/sims/kit/blocks/duts.sch
.subckt duts capture_local data_local q_0 q_1 q_2 q_3
*.ipin capture_local
*.ipin data_local
*.opin q_0
*.opin q_1
*.opin q_2
*.opin q_3
xu_dut1 data_local capture_local q_0 dffq_1
xu_dut2 data_local capture_local q_1 meta_dut_baseline
xu_dut3 data_local capture_local q_2 meta_dut_keeper
xu_dut4 data_local capture_local q_3 meta_dut_forward
.ends

* expanding   symbol:  ~/metastability-298/build/sims/kit/blocks/selector.sym # of pins=7
** sym_path: ~/metastability-298/build/sims/kit/blocks/selector.sym
** sch_path: ~/metastability-298/build/sims/kit/blocks/selector.sch
.subckt selector q_0 q_1 q_2 q_3 ui_in_3 uio_in_6 selected_q
*.ipin q_0
*.ipin q_1
*.ipin q_2
*.ipin q_3
*.ipin ui_in_3
*.ipin uio_in_6
*.opin selected_q
xselect_dut q_0 q_1 q_2 q_3 ui_in_3 uio_in_6 selected_q mux4_1
.ends

* expanding   symbol:  ~/metastability-298/build/sims/kit/blocks/delay.sym # of pins=3
** sym_path: ~/metastability-298/build/sims/kit/blocks/delay.sym
** sch_path: ~/metastability-298/build/sims/kit/blocks/delay.sch
.subckt delay capture_local ua_0 early_clk
*.ipin capture_local
*.ipin ua_0
*.opin early_clk
xiso0 capture_local capture_iso_b inv_1
xiso1 capture_iso_b capture_iso inv_2
xant_ctrl ua_0 antenna
xdelay capture_iso ua_0 early_clk delay_line
.ends

* expanding   symbol:  ~/metastability-298/build/sims/kit/blocks/early_observer.sym # of
*+ pins=3
** sym_path: ~/metastability-298/build/sims/kit/blocks/early_observer.sym
** sch_path: ~/metastability-298/build/sims/kit/blocks/early_observer.sch
.subckt early_observer early_clk selected_q early_q
*.ipin early_clk
*.ipin selected_q
*.opin early_q
xearly_observer selected_q early_clk early_q dffq_1
.ends

* expanding   symbol:  ~/metastability-298/build/sims/kit/blocks/monitors.sym # of pins=4
** sym_path: ~/metastability-298/build/sims/kit/blocks/monitors.sym
** sch_path: ~/metastability-298/build/sims/kit/blocks/monitors.sch
.subckt monitors capture_local early_clk uio_out_4 uio_out_5
*.ipin capture_local
*.ipin early_clk
*.opin uio_out_4
*.opin uio_out_5
xmonitor_capture_a capture_local capmon_n inv_1
xmonitor_capture_b capmon_n uio_out_4 inv_2
xmonitor_early_a early_clk earlymon_n inv_1
xmonitor_early_b earlymon_n uio_out_5 inv_2
.ends

* expanding   symbol:  ~/metastability-298/build/sims/kit/cells_tx/inv_2.sym # of pins=2
** sym_path: ~/metastability-298/build/sims/kit/cells_tx/inv_2.sym
** sch_path: ~/metastability-298/build/sims/kit/cells_tx/inv_2.sch
.subckt inv_2 I ZN
*.ipin I
*.opin ZN
XM_i_0_0 ZN I 0 0 nfet_05v0 L=0.6u W=0.82u nf=1 ad=4.1e-13 as=4.1e-13 pd=2.64e-06 ps=2.64e-06 nrd=0
+ nrs=0 sa=0 sb=0 sd=0 m=1
XM_i_0_1 ZN I 0 0 nfet_05v0 L=0.6u W=0.82u nf=1 ad=4.1e-13 as=4.1e-13 pd=2.64e-06 ps=2.64e-06 nrd=0
+ nrs=0 sa=0 sb=0 sd=0 m=1
XM_i_1_0 ZN I VDD VDD pfet_05v0 L=0.5u W=1.22u nf=1 ad=6.1e-13 as=6.1e-13 pd=3.44e-06 ps=3.44e-06
+ nrd=0 nrs=0 sa=0 sb=0 sd=0 m=1
XM_i_1_1 ZN I VDD VDD pfet_05v0 L=0.5u W=1.22u nf=1 ad=6.1e-13 as=6.1e-13 pd=3.44e-06 ps=3.44e-06
+ nrd=0 nrs=0 sa=0 sb=0 sd=0 m=1
.ends

* expanding   symbol:  ~/metastability-298/build/sims/kit/cells_tx/dffq_1.sym # of pins=3
** sym_path: ~/metastability-298/build/sims/kit/cells_tx/dffq_1.sym
** sch_path: ~/metastability-298/build/sims/kit/cells_tx/dffq_1.sch
.subckt dffq_1 D CLK Q
*.ipin D
*.ipin CLK
*.opin Q
XM_tn3 net1 CLK 0 0 nfet_05v0 L=0.6u W=0.405u nf=1 ad=2.025e-13 as=2.025e-13 pd=1.81e-06 ps=1.81e-06
+ nrd=0 nrs=0 sa=0 sb=0 sd=0 m=1
XM_tn4 net2 net1 0 0 nfet_05v0 L=0.6u W=0.405u nf=1 ad=2.025e-13 as=2.025e-13 pd=1.81e-06
+ ps=1.81e-06 nrd=0 nrs=0 sa=0 sb=0 sd=0 m=1
XM_tn5 net7 net1 0 0 nfet_05v0 L=0.6u W=0.36u nf=1 ad=1.8e-13 as=1.8e-13 pd=1.72e-06 ps=1.72e-06
+ nrd=0 nrs=0 sa=0 sb=0 sd=0 m=1
XM_tn8 net4 D net7 0 nfet_05v0 L=0.6u W=0.36u nf=1 ad=1.8e-13 as=1.8e-13 pd=1.72e-06 ps=1.72e-06
+ nrd=0 nrs=0 sa=0 sb=0 sd=0 m=1
XM_tn6 net4 net2 net8 0 nfet_05v0 L=0.6u W=0.36u nf=1 ad=1.8e-13 as=1.8e-13 pd=1.72e-06 ps=1.72e-06
+ nrd=0 nrs=0 sa=0 sb=0 sd=0 m=1
XM_tn7 net8 net6 0 0 nfet_05v0 L=0.6u W=0.36u nf=1 ad=1.8e-13 as=1.8e-13 pd=1.72e-06 ps=1.72e-06
+ nrd=0 nrs=0 sa=0 sb=0 sd=0 m=1
XM_tn0 net6 net4 0 0 nfet_05v0 L=0.6u W=0.36u nf=1 ad=1.8e-13 as=1.8e-13 pd=1.72e-06 ps=1.72e-06
+ nrd=0 nrs=0 sa=0 sb=0 sd=0 m=1
XM_tn9 net5 net2 net6 0 nfet_05v0 L=0.6u W=0.36u nf=1 ad=1.8e-13 as=1.8e-13 pd=1.72e-06 ps=1.72e-06
+ nrd=0 nrs=0 sa=0 sb=0 sd=0 m=1
XM_tn11 net5 net1 net9 0 nfet_05v0 L=0.6u W=0.36u nf=1 ad=1.8e-13 as=1.8e-13 pd=1.72e-06 ps=1.72e-06
+ nrd=0 nrs=0 sa=0 sb=0 sd=0 m=1
XM_tn12 net9 net3 0 0 nfet_05v0 L=0.6u W=0.36u nf=1 ad=1.8e-13 as=1.8e-13 pd=1.72e-06 ps=1.72e-06
+ nrd=0 nrs=0 sa=0 sb=0 sd=0 m=1
XM_tn10 net3 net5 0 0 nfet_05v0 L=0.6u W=0.4u nf=1 ad=2e-13 as=2e-13 pd=1.8e-06 ps=1.8e-06 nrd=0
+ nrs=0 sa=0 sb=0 sd=0 m=1
XM_tn1 Q net3 0 0 nfet_05v0 L=0.6u W=0.82u nf=1 ad=4.1e-13 as=4.1e-13 pd=2.64e-06 ps=2.64e-06 nrd=0
+ nrs=0 sa=0 sb=0 sd=0 m=1
XM_tp3 net1 CLK VDD VDD pfet_05v0 L=0.5u W=0.865u nf=1 ad=4.325e-13 as=4.325e-13 pd=2.73e-06
+ ps=2.73e-06 nrd=0 nrs=0 sa=0 sb=0 sd=0 m=1
XM_tp4 net2 net1 VDD VDD pfet_05v0 L=0.5u W=0.865u nf=1 ad=4.325e-13 as=4.325e-13 pd=2.73e-06
+ ps=2.73e-06 nrd=0 nrs=0 sa=0 sb=0 sd=0 m=1
XM_tp12 net10 net2 VDD VDD pfet_05v0 L=0.5u W=0.36u nf=1 ad=1.8e-13 as=1.8e-13 pd=1.72e-06
+ ps=1.72e-06 nrd=0 nrs=0 sa=0 sb=0 sd=0 m=1
XM_tp11 net4 D net10 VDD pfet_05v0 L=0.5u W=0.36u nf=1 ad=1.8e-13 as=1.8e-13 pd=1.72e-06 ps=1.72e-06
+ nrd=0 nrs=0 sa=0 sb=0 sd=0 m=1
XM_tp6 net4 net1 net11 VDD pfet_05v0 L=0.5u W=0.36u nf=1 ad=1.8e-13 as=1.8e-13 pd=1.72e-06
+ ps=1.72e-06 nrd=0 nrs=0 sa=0 sb=0 sd=0 m=1
XM_tp5 net11 net6 VDD VDD pfet_05v0 L=0.5u W=0.36u nf=1 ad=1.8e-13 as=1.8e-13 pd=1.72e-06
+ ps=1.72e-06 nrd=0 nrs=0 sa=0 sb=0 sd=0 m=1
XM_tp0 net6 net4 VDD VDD pfet_05v0 L=0.5u W=0.36u nf=1 ad=1.8e-13 as=1.8e-13 pd=1.72e-06 ps=1.72e-06
+ nrd=0 nrs=0 sa=0 sb=0 sd=0 m=1
XM_tp7 net5 net1 net6 VDD pfet_05v0 L=0.5u W=0.36u nf=1 ad=1.8e-13 as=1.8e-13 pd=1.72e-06
+ ps=1.72e-06 nrd=0 nrs=0 sa=0 sb=0 sd=0 m=1
XM_tp9 net5 net2 net12 VDD pfet_05v0 L=0.5u W=0.36u nf=1 ad=1.8e-13 as=1.8e-13 pd=1.72e-06
+ ps=1.72e-06 nrd=0 nrs=0 sa=0 sb=0 sd=0 m=1
XM_tp10 net12 net3 VDD VDD pfet_05v0 L=0.5u W=0.36u nf=1 ad=1.8e-13 as=1.8e-13 pd=1.72e-06
+ ps=1.72e-06 nrd=0 nrs=0 sa=0 sb=0 sd=0 m=1
XM_tp8 net3 net5 VDD VDD pfet_05v0 L=0.5u W=0.8u nf=1 ad=4e-13 as=4e-13 pd=2.6e-06 ps=2.6e-06 nrd=0
+ nrs=0 sa=0 sb=0 sd=0 m=1
XM_tp1 Q net3 VDD VDD pfet_05v0 L=0.5u W=1.22u nf=1 ad=6.1e-13 as=6.1e-13 pd=3.44e-06 ps=3.44e-06
+ nrd=0 nrs=0 sa=0 sb=0 sd=0 m=1
.ends

* expanding   symbol:  ~/metastability-298/build/sims/kit/blocks/meta_dut_baseline.sym #
*+ of pins=3
** sym_path: ~/metastability-298/build/sims/kit/blocks/meta_dut_baseline.sym
** sch_path: ~/metastability-298/build/sims/kit/blocks/meta_dut_baseline.sch
.subckt meta_dut_baseline d clk q
*.ipin d
*.ipin clk
*.opin q
xu_cki clk clkn inv_1
xu_mg1 d clkn g1 nand2_1
xu_mg2 g1 clkn g2 nand2_1
xu_mfw mqb g1 mq nand2_2
xu_mkp mq g2 mqb nand2_1
xu_sg1 mq clk s1 nand2_1
xu_sg2 s1 clk s2 nand2_1
xu_sfw sqb s1 q nand2_1
xu_skp q s2 sqb nand2_1
Cmq mq 0 0.25f m=1
Cmqb mqb 0 0.25f m=1
Cmut mq mqb 0.05f m=1
.ends

* expanding   symbol:  ~/metastability-298/build/sims/kit/blocks/meta_dut_keeper.sym # of
*+ pins=3
** sym_path: ~/metastability-298/build/sims/kit/blocks/meta_dut_keeper.sym
** sch_path: ~/metastability-298/build/sims/kit/blocks/meta_dut_keeper.sch
.subckt meta_dut_keeper d clk q
*.ipin d
*.ipin clk
*.opin q
xu_cki clk clkn inv_1
xu_mg1 d clkn g1 nand2_1
xu_mg2 g1 clkn g2 nand2_1
xu_mfw mqb g1 mq nand2_2
xu_mkp mq g2 mqb nand2_2
xu_sg1 mq clk s1 nand2_1
xu_sg2 s1 clk s2 nand2_1
xu_sfw sqb s1 q nand2_1
xu_skp q s2 sqb nand2_1
Cmq mq 0 0.25f m=1
Cmqb mqb 0 0.25f m=1
Cmut mq mqb 0.05f m=1
.ends

* expanding   symbol:  ~/metastability-298/build/sims/kit/blocks/meta_dut_forward.sym # of
*+ pins=3
** sym_path: ~/metastability-298/build/sims/kit/blocks/meta_dut_forward.sym
** sch_path: ~/metastability-298/build/sims/kit/blocks/meta_dut_forward.sch
.subckt meta_dut_forward d clk q
*.ipin d
*.ipin clk
*.opin q
xu_cki clk clkn inv_1
xu_mg1 d clkn g1 nand2_1
xu_mg2 g1 clkn g2 nand2_1
xu_mfw mqb g1 mq nand2_4
xu_mkp mq g2 mqb nand2_1
xu_sg1 mq clk s1 nand2_1
xu_sg2 s1 clk s2 nand2_1
xu_sfw sqb s1 q nand2_1
xu_skp q s2 sqb nand2_1
Cmq mq 0 0.25f m=1
Cmqb mqb 0 0.25f m=1
Cmut mq mqb 0.05f m=1
.ends

* expanding   symbol:  ~/metastability-298/build/sims/kit/cells_tx/mux4_1.sym # of pins=7
** sym_path: ~/metastability-298/build/sims/kit/cells_tx/mux4_1.sym
** sch_path: ~/metastability-298/build/sims/kit/cells_tx/mux4_1.sch
.subckt mux4_1 I0 I1 I2 I3 S0 S1 Z
*.ipin I0
*.ipin I1
*.ipin I2
*.ipin I3
*.ipin S0
*.ipin S1
*.opin Z
XM_MN5 net6 I2 0 0 nfet_05v0 L=0.6u W=0.365u nf=1 ad=1.825e-13 as=1.825e-13 pd=1.73e-06 ps=1.73e-06
+ nrd=0 nrs=0 sa=0 sb=0 sd=0 m=1
XM_MN9 net3 net1 net6 0 nfet_05v0 L=0.6u W=0.365u nf=1 ad=1.825e-13 as=1.825e-13 pd=1.73e-06
+ ps=1.73e-06 nrd=0 nrs=0 sa=0 sb=0 sd=0 m=1
XM_MN10 net3 S0 net7 0 nfet_05v0 L=0.6u W=0.365u nf=1 ad=1.825e-13 as=1.825e-13 pd=1.73e-06
+ ps=1.73e-06 nrd=0 nrs=0 sa=0 sb=0 sd=0 m=1
XM_MN6 net7 I3 0 0 nfet_05v0 L=0.6u W=0.365u nf=1 ad=1.825e-13 as=1.825e-13 pd=1.73e-06 ps=1.73e-06
+ nrd=0 nrs=0 sa=0 sb=0 sd=0 m=1
XM_instance_22 Z net2 0 0 nfet_05v0 L=0.6u W=0.38u nf=1 ad=1.9e-13 as=1.9e-13 pd=1.76e-06
+ ps=1.76e-06 nrd=0 nrs=0 sa=0 sb=0 sd=0 m=1
XM_MN12 net2 S1 net3 0 nfet_05v0 L=0.6u W=0.365u nf=1 ad=1.825e-13 as=1.825e-13 pd=1.73e-06
+ ps=1.73e-06 nrd=0 nrs=0 sa=0 sb=0 sd=0 m=1
XM_MN11 net2 net5 net4 0 nfet_05v0 L=0.6u W=0.365u nf=1 ad=1.825e-13 as=1.825e-13 pd=1.73e-06
+ ps=1.73e-06 nrd=0 nrs=0 sa=0 sb=0 sd=0 m=1
XM_MN2 net5 S1 0 0 nfet_05v0 L=0.6u W=0.365u nf=1 ad=1.825e-13 as=1.825e-13 pd=1.73e-06 ps=1.73e-06
+ nrd=0 nrs=0 sa=0 sb=0 sd=0 m=1
XM_MN4 net8 I1 0 0 nfet_05v0 L=0.6u W=0.365u nf=1 ad=1.825e-13 as=1.825e-13 pd=1.73e-06 ps=1.73e-06
+ nrd=0 nrs=0 sa=0 sb=0 sd=0 m=1
XM_MN8 net4 S0 net8 0 nfet_05v0 L=0.6u W=0.365u nf=1 ad=1.825e-13 as=1.825e-13 pd=1.73e-06
+ ps=1.73e-06 nrd=0 nrs=0 sa=0 sb=0 sd=0 m=1
XM_MN7 net4 net1 net9 0 nfet_05v0 L=0.6u W=0.365u nf=1 ad=1.825e-13 as=1.825e-13 pd=1.73e-06
+ ps=1.73e-06 nrd=0 nrs=0 sa=0 sb=0 sd=0 m=1
XM_MN3 net9 I0 0 0 nfet_05v0 L=0.6u W=0.365u nf=1 ad=1.825e-13 as=1.825e-13 pd=1.73e-06 ps=1.73e-06
+ nrd=0 nrs=0 sa=0 sb=0 sd=0 m=1
XM_MN1 net1 S0 0 0 nfet_05v0 L=0.6u W=0.365u nf=1 ad=1.825e-13 as=1.825e-13 pd=1.73e-06 ps=1.73e-06
+ nrd=0 nrs=0 sa=0 sb=0 sd=0 m=1
XM_MP2 net6 I2 VDD VDD pfet_05v0 L=0.5u W=0.565u nf=1 ad=2.825e-13 as=2.825e-13 pd=2.13e-06
+ ps=2.13e-06 nrd=0 nrs=0 sa=0 sb=0 sd=0 m=1
XM_MP9 net3 S0 net6 VDD pfet_05v0 L=0.5u W=0.565u nf=1 ad=2.825e-13 as=2.825e-13 pd=2.13e-06
+ ps=2.13e-06 nrd=0 nrs=0 sa=0 sb=0 sd=0 m=1
XM_MP10 net3 net1 net7 VDD pfet_05v0 L=0.5u W=0.565u nf=1 ad=2.825e-13 as=2.825e-13 pd=2.13e-06
+ ps=2.13e-06 nrd=0 nrs=0 sa=0 sb=0 sd=0 m=1
XM_MP6 net7 I3 VDD VDD pfet_05v0 L=0.5u W=0.565u nf=1 ad=2.825e-13 as=2.825e-13 pd=2.13e-06
+ ps=2.13e-06 nrd=0 nrs=0 sa=0 sb=0 sd=0 m=1
XM_instance_1 Z net2 VDD VDD pfet_05v0 L=0.5u W=0.78u nf=1 ad=3.9e-13 as=3.9e-13 pd=2.56e-06
+ ps=2.56e-06 nrd=0 nrs=0 sa=0 sb=0 sd=0 m=1
XM_MP12 net2 net5 net3 VDD pfet_05v0 L=0.5u W=0.565u nf=1 ad=2.825e-13 as=2.825e-13 pd=2.13e-06
+ ps=2.13e-06 nrd=0 nrs=0 sa=0 sb=0 sd=0 m=1
XM_MP11 net2 S1 net4 VDD pfet_05v0 L=0.5u W=0.565u nf=1 ad=2.825e-13 as=2.825e-13 pd=2.13e-06
+ ps=2.13e-06 nrd=0 nrs=0 sa=0 sb=0 sd=0 m=1
XM_MP5 net5 S1 VDD VDD pfet_05v0 L=0.5u W=0.565u nf=1 ad=2.825e-13 as=2.825e-13 pd=2.13e-06
+ ps=2.13e-06 nrd=0 nrs=0 sa=0 sb=0 sd=0 m=1
XM_MP4 net8 I1 VDD VDD pfet_05v0 L=0.5u W=0.565u nf=1 ad=2.825e-13 as=2.825e-13 pd=2.13e-06
+ ps=2.13e-06 nrd=0 nrs=0 sa=0 sb=0 sd=0 m=1
XM_MP8 net4 net1 net8 VDD pfet_05v0 L=0.5u W=0.565u nf=1 ad=2.825e-13 as=2.825e-13 pd=2.13e-06
+ ps=2.13e-06 nrd=0 nrs=0 sa=0 sb=0 sd=0 m=1
XM_MP7 net4 S0 net9 VDD pfet_05v0 L=0.5u W=0.565u nf=1 ad=2.825e-13 as=2.825e-13 pd=2.13e-06
+ ps=2.13e-06 nrd=0 nrs=0 sa=0 sb=0 sd=0 m=1
XM_MP3 net9 I0 VDD VDD pfet_05v0 L=0.5u W=0.565u nf=1 ad=2.825e-13 as=2.825e-13 pd=2.13e-06
+ ps=2.13e-06 nrd=0 nrs=0 sa=0 sb=0 sd=0 m=1
XM_MP1 net1 S0 VDD VDD pfet_05v0 L=0.5u W=0.565u nf=1 ad=2.825e-13 as=2.825e-13 pd=2.13e-06
+ ps=2.13e-06 nrd=0 nrs=0 sa=0 sb=0 sd=0 m=1
.ends

* expanding   symbol:  ~/metastability-298/build/sims/kit/cells_tx/inv_1.sym # of pins=2
** sym_path: ~/metastability-298/build/sims/kit/cells_tx/inv_1.sym
** sch_path: ~/metastability-298/build/sims/kit/cells_tx/inv_1.sch
.subckt inv_1 I ZN
*.ipin I
*.opin ZN
XM_i_0 ZN I 0 0 nfet_05v0 L=0.6u W=0.82u nf=1 ad=4.1e-13 as=4.1e-13 pd=2.64e-06 ps=2.64e-06 nrd=0
+ nrs=0 sa=0 sb=0 sd=0 m=1
XM_i_1 ZN I VDD VDD pfet_05v0 L=0.5u W=1.22u nf=1 ad=6.1e-13 as=6.1e-13 pd=3.44e-06 ps=3.44e-06
+ nrd=0 nrs=0 sa=0 sb=0 sd=0 m=1
.ends

* expanding   symbol:  ~/metastability-298/build/sims/kit/cells_tx/antenna.sym # of pins=1
** sym_path: ~/metastability-298/build/sims/kit/cells_tx/antenna.sym
** sch_path: ~/metastability-298/build/sims/kit/cells_tx/antenna.sch
.subckt antenna I
*.ipin I
D0 0 I diode_nd2ps_06v0 area=0.2052p pj=1.86u
D1 I VDD diode_pd2nw_06v0 area=0.2052p pj=1.86u
.ends

* expanding   symbol:  ~/metastability-298/build/sims/kit/blocks/delay_line.sym # of
*+ pins=3
** sym_path: ~/metastability-298/build/sims/kit/blocks/delay_line.sym
** sch_path: ~/metastability-298/build/sims/kit/blocks/delay_line.sch
.subckt delay_line launch control sample_clk
*.ipin launch
*.ipin control
*.opin sample_clk
XMP slow launch VDD VDD pfet_05v0 L=0.5u W=1.22u nf=1 ad=6.1e-13 as=6.1e-13 pd=3.44e-06 ps=3.44e-06
+ nrd=0 nrs=0 sa=0 sb=0 sd=0 m=1
XMN slow launch foot 0 nfet_05v0 L=0.6u W=0.82u nf=1 ad=4.1e-13 as=4.1e-13 pd=2.64e-06 ps=2.64e-06
+ nrd=0 nrs=0 sa=0 sb=0 sd=0 m=1
XMC foot control 0 0 nfet_05v0 L=0.6u W=0.36u nf=1 ad=1.8e-13 as=1.8e-13 pd=1.72e-06 ps=1.72e-06
+ nrd=0 nrs=0 sa=0 sb=0 sd=0 m=1
XMCT 0 slow 0 0 nfet_05v0 L=1u W=0.82u nf=1 ad=4.1e-13 as=4.1e-13 pd=2.64e-06 ps=2.64e-06 nrd=0
+ nrs=0 sa=0 sb=0 sd=0 m=1
xXR0 slow r0 inv_1
xXR1 r0 r1 inv_2
xXR2 r1 sample_clk inv_2
.ends

* expanding   symbol:  ~/metastability-298/build/sims/kit/cells_tx/nand2_1.sym # of pins=3
** sym_path: ~/metastability-298/build/sims/kit/cells_tx/nand2_1.sym
** sch_path: ~/metastability-298/build/sims/kit/cells_tx/nand2_1.sch
.subckt nand2_1 A1 A2 ZN
*.ipin A1
*.ipin A2
*.opin ZN
XM_i_1 net1 A2 0 0 nfet_05v0 L=0.6u W=0.82u nf=1 ad=4.1e-13 as=4.1e-13 pd=2.64e-06 ps=2.64e-06 nrd=0
+ nrs=0 sa=0 sb=0 sd=0 m=1
XM_i_0 ZN A1 net1 0 nfet_05v0 L=0.6u W=0.82u nf=1 ad=4.1e-13 as=4.1e-13 pd=2.64e-06 ps=2.64e-06
+ nrd=0 nrs=0 sa=0 sb=0 sd=0 m=1
XM_i_3 ZN A2 VDD VDD pfet_05v0 L=0.5u W=1.13u nf=1 ad=5.65e-13 as=5.65e-13 pd=3.26e-06 ps=3.26e-06
+ nrd=0 nrs=0 sa=0 sb=0 sd=0 m=1
XM_i_2 ZN A1 VDD VDD pfet_05v0 L=0.5u W=1.13u nf=1 ad=5.65e-13 as=5.65e-13 pd=3.26e-06 ps=3.26e-06
+ nrd=0 nrs=0 sa=0 sb=0 sd=0 m=1
.ends

* expanding   symbol:  ~/metastability-298/build/sims/kit/cells_tx/nand2_2.sym # of pins=3
** sym_path: ~/metastability-298/build/sims/kit/cells_tx/nand2_2.sym
** sch_path: ~/metastability-298/build/sims/kit/cells_tx/nand2_2.sch
.subckt nand2_2 A1 A2 ZN
*.ipin A1
*.ipin A2
*.opin ZN
XM_i_1_1 net1 A2 0 0 nfet_05v0 L=0.6u W=0.82u nf=1 ad=4.1e-13 as=4.1e-13 pd=2.64e-06 ps=2.64e-06
+ nrd=0 nrs=0 sa=0 sb=0 sd=0 m=1
XM_i_0_1 ZN A1 net1 0 nfet_05v0 L=0.6u W=0.82u nf=1 ad=4.1e-13 as=4.1e-13 pd=2.64e-06 ps=2.64e-06
+ nrd=0 nrs=0 sa=0 sb=0 sd=0 m=1
XM_i_0_0 ZN A1 net2 0 nfet_05v0 L=0.6u W=0.82u nf=1 ad=4.1e-13 as=4.1e-13 pd=2.64e-06 ps=2.64e-06
+ nrd=0 nrs=0 sa=0 sb=0 sd=0 m=1
XM_i_1_0 net2 A2 0 0 nfet_05v0 L=0.6u W=0.82u nf=1 ad=4.1e-13 as=4.1e-13 pd=2.64e-06 ps=2.64e-06
+ nrd=0 nrs=0 sa=0 sb=0 sd=0 m=1
XM_i_3_1 ZN A2 VDD VDD pfet_05v0 L=0.5u W=1.13u nf=1 ad=5.65e-13 as=5.65e-13 pd=3.26e-06 ps=3.26e-06
+ nrd=0 nrs=0 sa=0 sb=0 sd=0 m=1
XM_i_2_1 ZN A1 VDD VDD pfet_05v0 L=0.5u W=1.13u nf=1 ad=5.65e-13 as=5.65e-13 pd=3.26e-06 ps=3.26e-06
+ nrd=0 nrs=0 sa=0 sb=0 sd=0 m=1
XM_i_2_0 ZN A1 VDD VDD pfet_05v0 L=0.5u W=1.13u nf=1 ad=5.65e-13 as=5.65e-13 pd=3.26e-06 ps=3.26e-06
+ nrd=0 nrs=0 sa=0 sb=0 sd=0 m=1
XM_i_3_0 ZN A2 VDD VDD pfet_05v0 L=0.5u W=1.13u nf=1 ad=5.65e-13 as=5.65e-13 pd=3.26e-06 ps=3.26e-06
+ nrd=0 nrs=0 sa=0 sb=0 sd=0 m=1
.ends

* expanding   symbol:  ~/metastability-298/build/sims/kit/cells_tx/nand2_4.sym # of pins=3
** sym_path: ~/metastability-298/build/sims/kit/cells_tx/nand2_4.sym
** sch_path: ~/metastability-298/build/sims/kit/cells_tx/nand2_4.sch
.subckt nand2_4 A1 A2 ZN
*.ipin A1
*.ipin A2
*.opin ZN
XM_i_1_3 net1 A2 0 0 nfet_05v0 L=0.6u W=0.82u nf=1 ad=4.1e-13 as=4.1e-13 pd=2.64e-06 ps=2.64e-06
+ nrd=0 nrs=0 sa=0 sb=0 sd=0 m=1
XM_i_0_3 ZN A1 net1 0 nfet_05v0 L=0.6u W=0.82u nf=1 ad=4.1e-13 as=4.1e-13 pd=2.64e-06 ps=2.64e-06
+ nrd=0 nrs=0 sa=0 sb=0 sd=0 m=1
XM_i_0_2 ZN A1 net2 0 nfet_05v0 L=0.6u W=0.82u nf=1 ad=4.1e-13 as=4.1e-13 pd=2.64e-06 ps=2.64e-06
+ nrd=0 nrs=0 sa=0 sb=0 sd=0 m=1
XM_i_1_2 net2 A2 0 0 nfet_05v0 L=0.6u W=0.82u nf=1 ad=4.1e-13 as=4.1e-13 pd=2.64e-06 ps=2.64e-06
+ nrd=0 nrs=0 sa=0 sb=0 sd=0 m=1
XM_i_1_1 net3 A2 0 0 nfet_05v0 L=0.6u W=0.82u nf=1 ad=4.1e-13 as=4.1e-13 pd=2.64e-06 ps=2.64e-06
+ nrd=0 nrs=0 sa=0 sb=0 sd=0 m=1
XM_i_0_1 ZN A1 net3 0 nfet_05v0 L=0.6u W=0.82u nf=1 ad=4.1e-13 as=4.1e-13 pd=2.64e-06 ps=2.64e-06
+ nrd=0 nrs=0 sa=0 sb=0 sd=0 m=1
XM_i_0_0 ZN A1 net4 0 nfet_05v0 L=0.6u W=0.82u nf=1 ad=4.1e-13 as=4.1e-13 pd=2.64e-06 ps=2.64e-06
+ nrd=0 nrs=0 sa=0 sb=0 sd=0 m=1
XM_i_1_0 net4 A2 0 0 nfet_05v0 L=0.6u W=0.82u nf=1 ad=4.1e-13 as=4.1e-13 pd=2.64e-06 ps=2.64e-06
+ nrd=0 nrs=0 sa=0 sb=0 sd=0 m=1
XM_i_3_3 ZN A2 VDD VDD pfet_05v0 L=0.5u W=1.13u nf=1 ad=5.65e-13 as=5.65e-13 pd=3.26e-06 ps=3.26e-06
+ nrd=0 nrs=0 sa=0 sb=0 sd=0 m=1
XM_i_2_3 ZN A1 VDD VDD pfet_05v0 L=0.5u W=1.13u nf=1 ad=5.65e-13 as=5.65e-13 pd=3.26e-06 ps=3.26e-06
+ nrd=0 nrs=0 sa=0 sb=0 sd=0 m=1
XM_i_2_2 ZN A1 VDD VDD pfet_05v0 L=0.5u W=1.13u nf=1 ad=5.65e-13 as=5.65e-13 pd=3.26e-06 ps=3.26e-06
+ nrd=0 nrs=0 sa=0 sb=0 sd=0 m=1
XM_i_3_2 ZN A2 VDD VDD pfet_05v0 L=0.5u W=1.13u nf=1 ad=5.65e-13 as=5.65e-13 pd=3.26e-06 ps=3.26e-06
+ nrd=0 nrs=0 sa=0 sb=0 sd=0 m=1
XM_i_3_1 ZN A2 VDD VDD pfet_05v0 L=0.5u W=1.13u nf=1 ad=5.65e-13 as=5.65e-13 pd=3.26e-06 ps=3.26e-06
+ nrd=0 nrs=0 sa=0 sb=0 sd=0 m=1
XM_i_2_1 ZN A1 VDD VDD pfet_05v0 L=0.5u W=1.13u nf=1 ad=5.65e-13 as=5.65e-13 pd=3.26e-06 ps=3.26e-06
+ nrd=0 nrs=0 sa=0 sb=0 sd=0 m=1
XM_i_2_0 ZN A1 VDD VDD pfet_05v0 L=0.5u W=1.13u nf=1 ad=5.65e-13 as=5.65e-13 pd=3.26e-06 ps=3.26e-06
+ nrd=0 nrs=0 sa=0 sb=0 sd=0 m=1
XM_i_3_0 ZN A2 VDD VDD pfet_05v0 L=0.5u W=1.13u nf=1 ad=5.65e-13 as=5.65e-13 pd=3.26e-06 ps=3.26e-06
+ nrd=0 nrs=0 sa=0 sb=0 sd=0 m=1
.ends

.GLOBAL GND
.GLOBAL VDD
.end
