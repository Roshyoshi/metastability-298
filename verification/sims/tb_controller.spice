** sch_path: ~/metastability-298/build/sims/kit/benches/tb_controller.sch
**.subckt tb_controller
vvdd VDD GND 3.3
vclk clk GND PULSE(0 3.3 24.5n 0.1n 0.1n 24.9n 50n)
vrst rst_n GND PWL(0 0 100n 0 100.1n 3.3)
vstart ui_in_4 GND PWL(0 0 300n 0 300.1n 3.3)
vena ena GND 3.3
vbyte ui_in_0 GND 0
vdq selected_q GND 3.3
vea early_q GND 0
xctrl clk early_q ena rst_n selected_q ui_in_0 ui_in_4 capture uio_out_1 uio_out_2 uio_out_3
+ uo_out_0 uo_out_1 uo_out_2 uo_out_3 uo_out_4 uo_out_5 uo_out_6 uo_out_7 controller
**** begin user architecture code

.include ~/.ciel/ciel/gf180mcu/versions/e8daeda73ca8f5814dbc0b11d1d05802251a3750/gf180mcuD/libs.tech/ngspice/design.ngspice
.lib ~/.ciel/ciel/gf180mcu/versions/e8daeda73ca8f5814dbc0b11d1d05802251a3750/gf180mcuD/libs.tech/ngspice/sm141064.ngspice typical
.lib ~/.ciel/ciel/gf180mcu/versions/e8daeda73ca8f5814dbc0b11d1d05802251a3750/gf180mcuD/libs.tech/ngspice/sm141064.ngspice diode_typical
.global VDD
.param sw_stat_global=0 sw_stat_mismatch=0
.control
set filetype=ascii
tran 50p 2.5u
meas tran first_cap when v(capture)=1.65 rise=1
let a=first_cap*1e9
echo RESULT first_capture_ns $&a
meas tran first_cnt when v(uo_out_0)=1.65 rise=1
let a=first_cnt*1e9
echo RESULT first_count_ns $&a
meas tran b0 find v(uo_out_0) at=2.49u
meas tran b1 find v(uo_out_1) at=2.49u
meas tran b2 find v(uo_out_2) at=2.49u
meas tran b3 find v(uo_out_3) at=2.49u
meas tran b4 find v(uo_out_4) at=2.49u
meas tran b5 find v(uo_out_5) at=2.49u
meas tran b6 find v(uo_out_6) at=2.49u
meas tran b7 find v(uo_out_7) at=2.49u
let ev=(b0 gt 1.65)+2*(b1 gt 1.65)+4*(b2 gt 1.65)+8*(b3 gt 1.65)+16*(b4 gt 1.65)+32*(b5 gt
+ 1.65)+64*(b6 gt 1.65)+128*(b7 gt 1.65)
echo RESULT events_after_8_trials $&ev
meas tran busy find v(uio_out_1) at=2.49u
meas tran done find v(uio_out_2) at=2.49u
meas tran fault find v(uio_out_3) at=2.49u
echo RESULT busy_V $&busy
echo RESULT done_V $&done
echo RESULT fault_V $&fault
wrdata tb_controller.dat v(clk) v(capture) v(uio_out_1) v(uo_out_0) v(uo_out_1) v(uo_out_2)
+ v(uo_out_3) v(uo_out_4) v(uo_out_5) v(uo_out_6) v(uo_out_7)
.endc

**** end user architecture code
**.ends

* expanding   symbol:  ~/metastability-298/build/sims/kit/blocks/controller.sym # of
*+ pins=19
** sym_path: ~/metastability-298/build/sims/kit/blocks/controller.sym
** sch_path: ~/metastability-298/build/sims/kit/blocks/controller.sch
.subckt controller clk early_q ena rst_n selected_q ui_in_0 ui_in_4 capture uio_out_1 uio_out_2
+ uio_out_3 uo_out_0 uo_out_1 uo_out_2 uo_out_3 uo_out_4 uo_out_5 uo_out_6 uo_out_7
xtrial_clock clk rst_n a_n b capture trial_clock
xstart a_n ena rst_n ui_in_4 run start
xreadings a_n b early_q selected_q bad_bit event_bit readings
xcount_pulse b n_16 rst_n run tick_n count_pulse
xtrial_counter run tick_n n_16 trial_counter
xevent_counter event_bit run tick_n k_0 k_10 k_11 k_12 k_13 k_14 k_15 k_1 k_2 k_3 k_4 k_5 k_6 k_7
+ k_8 k_9 event_counter
xstatus b bad_bit n_16 run tick_n uio_out_1 uio_out_2 uio_out_3 status
xreadout k_0 k_10 k_11 k_12 k_13 k_14 k_15 k_1 k_2 k_3 k_4 k_5 k_6 k_7 k_8 k_9 ui_in_0 uo_out_0
+ uo_out_1 uo_out_2 uo_out_3 uo_out_4 uo_out_5 uo_out_6 uo_out_7 readout
.ends

* expanding   symbol:  ~/metastability-298/build/sims/kit/blocks/trial_clock.sym # of
*+ pins=5
** sym_path: ~/metastability-298/build/sims/kit/blocks/trial_clock.sym
** sch_path: ~/metastability-298/build/sims/kit/blocks/trial_clock.sch
.subckt trial_clock clk rst_n a_n b capture
*.ipin clk
*.ipin rst_n
*.opin a_n
*.opin b
*.opin capture
xa_ff b clk capture dffq_1
xa_inv capture a_n inv_1
xb_ff a_n rst_n clk b dffrnq_1
.ends

* expanding   symbol:  ~/metastability-298/build/sims/kit/blocks/start.sym # of pins=5
** sym_path: ~/metastability-298/build/sims/kit/blocks/start.sym
** sch_path: ~/metastability-298/build/sims/kit/blocks/start.sch
.subckt start a_n ena rst_n ui_in_4 run
*.ipin a_n
*.ipin ena
*.ipin rst_n
*.ipin ui_in_4
*.opin run
xrequest_and ena ui_in_4 request and2_1
xrun_ff start_meta rst_n a_n run dffrnq_1
xstart_meta_ff request rst_n a_n start_meta dffrnq_1
.ends

* expanding   symbol:  ~/metastability-298/build/sims/kit/blocks/readings.sym # of pins=6
** sym_path: ~/metastability-298/build/sims/kit/blocks/readings.sym
** sch_path: ~/metastability-298/build/sims/kit/blocks/readings.sch
.subckt readings a_n b early_q selected_q bad_bit event_bit
*.ipin a_n
*.ipin b
*.ipin early_q
*.ipin selected_q
*.opin bad_bit
*.opin event_bit
xbad_xor l1 l2 bad_bit xor2_1
xevent_xor early_q l2 event_bit xor2_1
xl1_ff selected_q b l1 dffnq_1
xl2_ff selected_q a_n l2 dffq_1
.ends

* expanding   symbol:  ~/metastability-298/build/sims/kit/blocks/count_pulse.sym # of
*+ pins=5
** sym_path: ~/metastability-298/build/sims/kit/blocks/count_pulse.sym
** sch_path: ~/metastability-298/build/sims/kit/blocks/count_pulse.sch
.subckt count_pulse b n_16 rst_n run tick_n
*.ipin b
*.ipin n_16
*.ipin rst_n
*.ipin run
*.opin tick_n
xallow_ff want_count rst_n b allow_count dffnrnq_1
xfinished_inv n_16 finished_n inv_1
xtick_nand b allow_count tick_n nand2_1
xwant_and run finished_n want_count and2_1
.ends

* expanding   symbol:  ~/metastability-298/build/sims/kit/blocks/trial_counter.sym # of
*+ pins=3
** sym_path: ~/metastability-298/build/sims/kit/blocks/trial_counter.sym
** sch_path: ~/metastability-298/build/sims/kit/blocks/trial_counter.sch
.subckt trial_counter run tick_n n_16
*.ipin run
*.ipin tick_n
*.opin n_16
xn0_ff n_n_0 run tick_n n_0 dffnrnq_1
xn0_inv n_0 n_n_0 inv_1
xn10_ff n_n_10 run n_9 n_10 dffnrnq_1
xn10_inv n_10 n_n_10 inv_1
xn11_ff n_n_11 run n_10 n_11 dffnrnq_1
xn11_inv n_11 n_n_11 inv_1
xn12_ff n_n_12 run n_11 n_12 dffnrnq_1
xn12_inv n_12 n_n_12 inv_1
xn13_ff n_n_13 run n_12 n_13 dffnrnq_1
xn13_inv n_13 n_n_13 inv_1
xn14_ff n_n_14 run n_13 n_14 dffnrnq_1
xn14_inv n_14 n_n_14 inv_1
xn15_ff n_n_15 run n_14 n_15 dffnrnq_1
xn15_inv n_15 n_n_15 inv_1
xn16_ff n_n_16 run n_15 n_16 dffnrnq_1
xn16_inv n_16 n_n_16 inv_1
xn1_ff n_n_1 run n_n_0 n_1 dffnrnq_1
xn1_inv n_1 n_n_1 inv_1
xn2_ff n_n_2 run n_1 n_2 dffnrnq_1
xn2_inv n_2 n_n_2 inv_1
xn3_ff n_n_3 run n_2 n_3 dffnrnq_1
xn3_inv n_3 n_n_3 inv_1
xn4_ff n_n_4 run n_3 n_4 dffnrnq_1
xn4_inv n_4 n_n_4 inv_1
xn5_ff n_n_5 run n_4 n_5 dffnrnq_1
xn5_inv n_5 n_n_5 inv_1
xn6_ff n_n_6 run n_5 n_6 dffnrnq_1
xn6_inv n_6 n_n_6 inv_1
xn7_ff n_n_7 run n_6 n_7 dffnrnq_1
xn7_inv n_7 n_n_7 inv_1
xn8_ff n_n_8 run n_7 n_8 dffnrnq_1
xn8_inv n_8 n_n_8 inv_1
xn9_ff n_n_9 run n_8 n_9 dffnrnq_1
xn9_inv n_9 n_n_9 inv_1
.ends

* expanding   symbol:  ~/metastability-298/build/sims/kit/blocks/event_counter.sym # of
*+ pins=19
** sym_path: ~/metastability-298/build/sims/kit/blocks/event_counter.sym
** sch_path: ~/metastability-298/build/sims/kit/blocks/event_counter.sch
.subckt event_counter event_bit run tick_n k_0 k_10 k_11 k_12 k_13 k_14 k_15 k_1 k_2 k_3 k_4 k_5 k_6
+ k_7 k_8 k_9
*.ipin event_bit
*.ipin run
*.ipin tick_n
*.opin k_0
*.opin k_10
*.opin k_11
*.opin k_12
*.opin k_13
*.opin k_14
*.opin k_15
*.opin k_1
*.opin k_2
*.opin k_3
*.opin k_4
*.opin k_5
*.opin k_6
*.opin k_7
*.opin k_8
*.opin k_9
xk10_ff k_n_10 run k_9 k_10 dffnrnq_1
xk10_inv k_10 k_n_10 inv_1
xk11_ff k_n_11 run k_10 k_11 dffnrnq_1
xk11_inv k_11 k_n_11 inv_1
xk12_ff k_n_12 run k_11 k_12 dffnrnq_1
xk12_inv k_12 k_n_12 inv_1
xk13_ff k_n_13 run k_12 k_13 dffnrnq_1
xk13_inv k_13 k_n_13 inv_1
xk14_ff k_n_14 run k_13 k_14 dffnrnq_1
xk14_inv k_14 k_n_14 inv_1
xk15_ff k_n_15 run k_14 k_15 dffnrnq_1
xk15_inv k_15 k_n_15 inv_1
xk1_ff k_n_1 run k_0 k_1 dffnrnq_1
xk1_inv k_1 k_n_1 inv_1
xk2_ff k_n_2 run k_1 k_2 dffnrnq_1
xk2_inv k_2 k_n_2 inv_1
xk3_ff k_n_3 run k_2 k_3 dffnrnq_1
xk3_inv k_3 k_n_3 inv_1
xk4_ff k_n_4 run k_3 k_4 dffnrnq_1
xk4_inv k_4 k_n_4 inv_1
xk5_ff k_n_5 run k_4 k_5 dffnrnq_1
xk5_inv k_5 k_n_5 inv_1
xk6_ff k_n_6 run k_5 k_6 dffnrnq_1
xk6_inv k_6 k_n_6 inv_1
xk7_ff k_n_7 run k_6 k_7 dffnrnq_1
xk7_inv k_7 k_n_7 inv_1
xk8_ff k_n_8 run k_7 k_8 dffnrnq_1
xk8_inv k_8 k_n_8 inv_1
xk9_ff k_n_9 run k_8 k_9 dffnrnq_1
xk9_inv k_9 k_n_9 inv_1
xk0_ff k0_d run tick_n k_0 dffnrnq_1
xk0_xor k_0 event_bit k0_d xor2_1
.ends

* expanding   symbol:  ~/metastability-298/build/sims/kit/blocks/status.sym # of pins=8
** sym_path: ~/metastability-298/build/sims/kit/blocks/status.sym
** sch_path: ~/metastability-298/build/sims/kit/blocks/status.sch
.subckt status b bad_bit n_16 run tick_n uio_out_1 uio_out_2 uio_out_3
*.ipin b
*.ipin bad_bit
*.ipin n_16
*.ipin run
*.ipin tick_n
*.opin uio_out_1
*.opin uio_out_2
*.opin uio_out_3
xbusy_and run done_n uio_out_1 and2_1
xdone_ff n_16 run b uio_out_2 dffnrnq_1
xdone_inv uio_out_2 done_n inv_1
xfault_ff fault_d run tick_n uio_out_3 dffnrnq_1
xfault_or uio_out_3 bad_bit fault_d or2_1
.ends

* expanding   symbol:  ~/metastability-298/build/sims/kit/blocks/readout.sym # of pins=25
** sym_path: ~/metastability-298/build/sims/kit/blocks/readout.sym
** sch_path: ~/metastability-298/build/sims/kit/blocks/readout.sch
.subckt readout k_0 k_10 k_11 k_12 k_13 k_14 k_15 k_1 k_2 k_3 k_4 k_5 k_6 k_7 k_8 k_9 ui_in_0
+ uo_out_0 uo_out_1 uo_out_2 uo_out_3 uo_out_4 uo_out_5 uo_out_6 uo_out_7
*.ipin k_0
*.ipin k_10
*.ipin k_11
*.ipin k_12
*.ipin k_13
*.ipin k_14
*.ipin k_15
*.ipin k_1
*.ipin k_2
*.ipin k_3
*.ipin k_4
*.ipin k_5
*.ipin k_6
*.ipin k_7
*.ipin k_8
*.ipin k_9
*.ipin ui_in_0
*.opin uo_out_0
*.opin uo_out_1
*.opin uo_out_2
*.opin uo_out_3
*.opin uo_out_4
*.opin uo_out_5
*.opin uo_out_6
*.opin uo_out_7
xbyte0_mux k_0 k_8 ui_in_0 uo_out_0 mux2_1
xbyte1_mux k_1 k_9 ui_in_0 uo_out_1 mux2_1
xbyte2_mux k_2 k_10 ui_in_0 uo_out_2 mux2_1
xbyte3_mux k_3 k_11 ui_in_0 uo_out_3 mux2_1
xbyte4_mux k_4 k_12 ui_in_0 uo_out_4 mux2_1
xbyte5_mux k_5 k_13 ui_in_0 uo_out_5 mux2_1
xbyte6_mux k_6 k_14 ui_in_0 uo_out_6 mux2_1
xbyte7_mux k_7 k_15 ui_in_0 uo_out_7 mux2_1
.ends

* expanding   symbol:  ~/metastability-298/build/sims/kit/cells_tx/dffq_1.sym # of pins=3
** sym_path: ~/metastability-298/build/sims/kit/cells_tx/dffq_1.sym
** sch_path: ~/metastability-298/build/sims/kit/cells_tx/dffq_1.sch
.subckt dffq_1 D CLK Q
*.ipin D
*.ipin CLK
*.opin Q
XM_tn3 net1 CLK 0 0 nfet_05v0 L=0.6u W=0.405u nf=1 ad=2.025e-13 as=2.025e-13 pd=1.81e-06 ps=1.81e-06
+ nrd=0 nrs=0 sa=0 sb=0 sd=0 m=1
XM_tn4 net2 net1 0 0 nfet_05v0 L=0.6u W=0.405u nf=1 ad=2.025e-13 as=2.025e-13 pd=1.81e-06
+ ps=1.81e-06 nrd=0 nrs=0 sa=0 sb=0 sd=0 m=1
XM_tn5 net7 net1 0 0 nfet_05v0 L=0.6u W=0.36u nf=1 ad=1.8e-13 as=1.8e-13 pd=1.72e-06 ps=1.72e-06
+ nrd=0 nrs=0 sa=0 sb=0 sd=0 m=1
XM_tn8 net4 D net7 0 nfet_05v0 L=0.6u W=0.36u nf=1 ad=1.8e-13 as=1.8e-13 pd=1.72e-06 ps=1.72e-06
+ nrd=0 nrs=0 sa=0 sb=0 sd=0 m=1
XM_tn6 net4 net2 net8 0 nfet_05v0 L=0.6u W=0.36u nf=1 ad=1.8e-13 as=1.8e-13 pd=1.72e-06 ps=1.72e-06
+ nrd=0 nrs=0 sa=0 sb=0 sd=0 m=1
XM_tn7 net8 net6 0 0 nfet_05v0 L=0.6u W=0.36u nf=1 ad=1.8e-13 as=1.8e-13 pd=1.72e-06 ps=1.72e-06
+ nrd=0 nrs=0 sa=0 sb=0 sd=0 m=1
XM_tn0 net6 net4 0 0 nfet_05v0 L=0.6u W=0.36u nf=1 ad=1.8e-13 as=1.8e-13 pd=1.72e-06 ps=1.72e-06
+ nrd=0 nrs=0 sa=0 sb=0 sd=0 m=1
XM_tn9 net5 net2 net6 0 nfet_05v0 L=0.6u W=0.36u nf=1 ad=1.8e-13 as=1.8e-13 pd=1.72e-06 ps=1.72e-06
+ nrd=0 nrs=0 sa=0 sb=0 sd=0 m=1
XM_tn11 net5 net1 net9 0 nfet_05v0 L=0.6u W=0.36u nf=1 ad=1.8e-13 as=1.8e-13 pd=1.72e-06 ps=1.72e-06
+ nrd=0 nrs=0 sa=0 sb=0 sd=0 m=1
XM_tn12 net9 net3 0 0 nfet_05v0 L=0.6u W=0.36u nf=1 ad=1.8e-13 as=1.8e-13 pd=1.72e-06 ps=1.72e-06
+ nrd=0 nrs=0 sa=0 sb=0 sd=0 m=1
XM_tn10 net3 net5 0 0 nfet_05v0 L=0.6u W=0.4u nf=1 ad=2e-13 as=2e-13 pd=1.8e-06 ps=1.8e-06 nrd=0
+ nrs=0 sa=0 sb=0 sd=0 m=1
XM_tn1 Q net3 0 0 nfet_05v0 L=0.6u W=0.82u nf=1 ad=4.1e-13 as=4.1e-13 pd=2.64e-06 ps=2.64e-06 nrd=0
+ nrs=0 sa=0 sb=0 sd=0 m=1
XM_tp3 net1 CLK VDD VDD pfet_05v0 L=0.5u W=0.865u nf=1 ad=4.325e-13 as=4.325e-13 pd=2.73e-06
+ ps=2.73e-06 nrd=0 nrs=0 sa=0 sb=0 sd=0 m=1
XM_tp4 net2 net1 VDD VDD pfet_05v0 L=0.5u W=0.865u nf=1 ad=4.325e-13 as=4.325e-13 pd=2.73e-06
+ ps=2.73e-06 nrd=0 nrs=0 sa=0 sb=0 sd=0 m=1
XM_tp12 net10 net2 VDD VDD pfet_05v0 L=0.5u W=0.36u nf=1 ad=1.8e-13 as=1.8e-13 pd=1.72e-06
+ ps=1.72e-06 nrd=0 nrs=0 sa=0 sb=0 sd=0 m=1
XM_tp11 net4 D net10 VDD pfet_05v0 L=0.5u W=0.36u nf=1 ad=1.8e-13 as=1.8e-13 pd=1.72e-06 ps=1.72e-06
+ nrd=0 nrs=0 sa=0 sb=0 sd=0 m=1
XM_tp6 net4 net1 net11 VDD pfet_05v0 L=0.5u W=0.36u nf=1 ad=1.8e-13 as=1.8e-13 pd=1.72e-06
+ ps=1.72e-06 nrd=0 nrs=0 sa=0 sb=0 sd=0 m=1
XM_tp5 net11 net6 VDD VDD pfet_05v0 L=0.5u W=0.36u nf=1 ad=1.8e-13 as=1.8e-13 pd=1.72e-06
+ ps=1.72e-06 nrd=0 nrs=0 sa=0 sb=0 sd=0 m=1
XM_tp0 net6 net4 VDD VDD pfet_05v0 L=0.5u W=0.36u nf=1 ad=1.8e-13 as=1.8e-13 pd=1.72e-06 ps=1.72e-06
+ nrd=0 nrs=0 sa=0 sb=0 sd=0 m=1
XM_tp7 net5 net1 net6 VDD pfet_05v0 L=0.5u W=0.36u nf=1 ad=1.8e-13 as=1.8e-13 pd=1.72e-06
+ ps=1.72e-06 nrd=0 nrs=0 sa=0 sb=0 sd=0 m=1
XM_tp9 net5 net2 net12 VDD pfet_05v0 L=0.5u W=0.36u nf=1 ad=1.8e-13 as=1.8e-13 pd=1.72e-06
+ ps=1.72e-06 nrd=0 nrs=0 sa=0 sb=0 sd=0 m=1
XM_tp10 net12 net3 VDD VDD pfet_05v0 L=0.5u W=0.36u nf=1 ad=1.8e-13 as=1.8e-13 pd=1.72e-06
+ ps=1.72e-06 nrd=0 nrs=0 sa=0 sb=0 sd=0 m=1
XM_tp8 net3 net5 VDD VDD pfet_05v0 L=0.5u W=0.8u nf=1 ad=4e-13 as=4e-13 pd=2.6e-06 ps=2.6e-06 nrd=0
+ nrs=0 sa=0 sb=0 sd=0 m=1
XM_tp1 Q net3 VDD VDD pfet_05v0 L=0.5u W=1.22u nf=1 ad=6.1e-13 as=6.1e-13 pd=3.44e-06 ps=3.44e-06
+ nrd=0 nrs=0 sa=0 sb=0 sd=0 m=1
.ends

* expanding   symbol:  ~/metastability-298/build/sims/kit/cells_tx/inv_1.sym # of pins=2
** sym_path: ~/metastability-298/build/sims/kit/cells_tx/inv_1.sym
** sch_path: ~/metastability-298/build/sims/kit/cells_tx/inv_1.sch
.subckt inv_1 I ZN
*.ipin I
*.opin ZN
XM_i_0 ZN I 0 0 nfet_05v0 L=0.6u W=0.82u nf=1 ad=4.1e-13 as=4.1e-13 pd=2.64e-06 ps=2.64e-06 nrd=0
+ nrs=0 sa=0 sb=0 sd=0 m=1
XM_i_1 ZN I VDD VDD pfet_05v0 L=0.5u W=1.22u nf=1 ad=6.1e-13 as=6.1e-13 pd=3.44e-06 ps=3.44e-06
+ nrd=0 nrs=0 sa=0 sb=0 sd=0 m=1
.ends

* expanding   symbol:  ~/metastability-298/build/sims/kit/cells_tx/dffrnq_1.sym # of
*+ pins=4
** sym_path: ~/metastability-298/build/sims/kit/cells_tx/dffrnq_1.sym
** sch_path: ~/metastability-298/build/sims/kit/cells_tx/dffrnq_1.sch
.subckt dffrnq_1 D RN CLK Q
*.ipin D
*.ipin RN
*.ipin CLK
*.opin Q
XM_tn10 net1 CLK 0 0 nfet_05v0 L=0.6u W=0.405u nf=1 ad=2.025e-13 as=2.025e-13 pd=1.81e-06
+ ps=1.81e-06 nrd=0 nrs=0 sa=0 sb=0 sd=0 m=1
XM_tn13 net3 net1 0 0 nfet_05v0 L=0.6u W=0.405u nf=1 ad=2.025e-13 as=2.025e-13 pd=1.81e-06
+ ps=1.81e-06 nrd=0 nrs=0 sa=0 sb=0 sd=0 m=1
XM_tn11 net7 D 0 0 nfet_05v0 L=0.6u W=0.36u nf=1 ad=1.8e-13 as=1.8e-13 pd=1.72e-06 ps=1.72e-06 nrd=0
+ nrs=0 sa=0 sb=0 sd=0 m=1
XM_tn15 net4 net1 net7 0 nfet_05v0 L=0.6u W=0.36u nf=1 ad=1.8e-13 as=1.8e-13 pd=1.72e-06 ps=1.72e-06
+ nrd=0 nrs=0 sa=0 sb=0 sd=0 m=1
XM_tn14 net4 net3 net10 0 nfet_05v0 L=0.6u W=0.36u nf=1 ad=1.8e-13 as=1.8e-13 pd=1.72e-06
+ ps=1.72e-06 nrd=0 nrs=0 sa=0 sb=0 sd=0 m=1
XM_tn8 net10 net5 net11 0 nfet_05v0 L=0.6u W=0.36u nf=1 ad=1.8e-13 as=1.8e-13 pd=1.72e-06
+ ps=1.72e-06 nrd=0 nrs=0 sa=0 sb=0 sd=0 m=1
XM_tn9 net11 RN 0 0 nfet_05v0 L=0.6u W=0.36u nf=1 ad=1.8e-13 as=1.8e-13 pd=1.72e-06 ps=1.72e-06
+ nrd=0 nrs=0 sa=0 sb=0 sd=0 m=1
XM_tn18 net5 net4 0 0 nfet_05v0 L=0.6u W=0.36u nf=1 ad=1.8e-13 as=1.8e-13 pd=1.72e-06 ps=1.72e-06
+ nrd=0 nrs=0 sa=0 sb=0 sd=0 m=1
XM_tn0 net6 net3 net5 0 nfet_05v0 L=0.6u W=0.36u nf=1 ad=1.8e-13 as=1.8e-13 pd=1.72e-06 ps=1.72e-06
+ nrd=0 nrs=0 sa=0 sb=0 sd=0 m=1
XM_tn1 net6 net1 net8 0 nfet_05v0 L=0.6u W=0.36u nf=1 ad=1.8e-13 as=1.8e-13 pd=1.72e-06 ps=1.72e-06
+ nrd=0 nrs=0 sa=0 sb=0 sd=0 m=1
XM_tn12 net8 net2 0 0 nfet_05v0 L=0.6u W=0.36u nf=1 ad=1.8e-13 as=1.8e-13 pd=1.72e-06 ps=1.72e-06
+ nrd=0 nrs=0 sa=0 sb=0 sd=0 m=1
XM_tn5 net12 RN 0 0 nfet_05v0 L=0.6u W=0.36u nf=1 ad=1.8e-13 as=1.8e-13 pd=1.72e-06 ps=1.72e-06
+ nrd=0 nrs=0 sa=0 sb=0 sd=0 m=1
XM_tn4 net2 net6 net12 0 nfet_05v0 L=0.6u W=0.4u nf=1 ad=2e-13 as=2e-13 pd=1.8e-06 ps=1.8e-06 nrd=0
+ nrs=0 sa=0 sb=0 sd=0 m=1
XM_tn3 Q net2 0 0 nfet_05v0 L=0.6u W=0.815u nf=1 ad=4.075e-13 as=4.075e-13 pd=2.63e-06 ps=2.63e-06
+ nrd=0 nrs=0 sa=0 sb=0 sd=0 m=1
XM_tp8 net1 CLK VDD VDD pfet_05v0 L=0.5u W=0.865u nf=1 ad=4.325e-13 as=4.325e-13 pd=2.73e-06
+ ps=2.73e-06 nrd=0 nrs=0 sa=0 sb=0 sd=0 m=1
XM_tp11 net3 net1 VDD VDD pfet_05v0 L=0.5u W=0.865u nf=1 ad=4.325e-13 as=4.325e-13 pd=2.73e-06
+ ps=2.73e-06 nrd=0 nrs=0 sa=0 sb=0 sd=0 m=1
XM_tp9 net7 D VDD VDD pfet_05v0 L=0.5u W=0.78u nf=1 ad=3.9e-13 as=3.9e-13 pd=2.56e-06 ps=2.56e-06
+ nrd=0 nrs=0 sa=0 sb=0 sd=0 m=1
XM_tp15 net4 net3 net7 VDD pfet_05v0 L=0.5u W=0.78u nf=1 ad=3.9e-13 as=3.9e-13 pd=2.56e-06
+ ps=2.56e-06 nrd=0 nrs=0 sa=0 sb=0 sd=0 m=1
XM_tp7 net4 net1 net9 VDD pfet_05v0 L=0.5u W=0.78u nf=1 ad=3.9e-13 as=3.9e-13 pd=2.56e-06
+ ps=2.56e-06 nrd=0 nrs=0 sa=0 sb=0 sd=0 m=1
XM_tp6 net9 net5 VDD VDD pfet_05v0 L=0.5u W=0.78u nf=1 ad=3.9e-13 as=3.9e-13 pd=2.56e-06 ps=2.56e-06
+ nrd=0 nrs=0 sa=0 sb=0 sd=0 m=1
XM_tp12 net9 RN VDD VDD pfet_05v0 L=0.5u W=0.78u nf=1 ad=3.9e-13 as=3.9e-13 pd=2.56e-06 ps=2.56e-06
+ nrd=0 nrs=0 sa=0 sb=0 sd=0 m=1
XM_tp18 net5 net4 VDD VDD pfet_05v0 L=0.5u W=0.505u nf=1 ad=2.525e-13 as=2.525e-13 pd=2.01e-06
+ ps=2.01e-06 nrd=0 nrs=0 sa=0 sb=0 sd=0 m=1
XM_tp2 net6 net1 net5 VDD pfet_05v0 L=0.5u W=0.505u nf=1 ad=2.525e-13 as=2.525e-13 pd=2.01e-06
+ ps=2.01e-06 nrd=0 nrs=0 sa=0 sb=0 sd=0 m=1
XM_tp3 net6 net3 net8 VDD pfet_05v0 L=0.5u W=0.505u nf=1 ad=2.525e-13 as=2.525e-13 pd=2.01e-06
+ ps=2.01e-06 nrd=0 nrs=0 sa=0 sb=0 sd=0 m=1
XM_tp10 net8 net2 VDD VDD pfet_05v0 L=0.5u W=0.505u nf=1 ad=2.525e-13 as=2.525e-13 pd=2.01e-06
+ ps=2.01e-06 nrd=0 nrs=0 sa=0 sb=0 sd=0 m=1
XM_tp5 net2 RN VDD VDD pfet_05v0 L=0.5u W=1u nf=1 ad=5e-13 as=5e-13 pd=3e-06 ps=3e-06 nrd=0 nrs=0
+ sa=0 sb=0 sd=0 m=1
XM_tp4 net2 net6 VDD VDD pfet_05v0 L=0.5u W=1u nf=1 ad=5e-13 as=5e-13 pd=3e-06 ps=3e-06 nrd=0 nrs=0
+ sa=0 sb=0 sd=0 m=1
XM_tp1 Q net2 VDD VDD pfet_05v0 L=0.5u W=1.215u nf=1 ad=6.075e-13 as=6.075e-13 pd=3.43e-06
+ ps=3.43e-06 nrd=0 nrs=0 sa=0 sb=0 sd=0 m=1
.ends

* expanding   symbol:  ~/metastability-298/build/sims/kit/cells_tx/and2_1.sym # of pins=3
** sym_path: ~/metastability-298/build/sims/kit/cells_tx/and2_1.sym
** sch_path: ~/metastability-298/build/sims/kit/cells_tx/and2_1.sch
.subckt and2_1 A1 A2 Z
*.ipin A1
*.ipin A2
*.opin Z
XM_i_2 net1 A1 net2 0 nfet_05v0 L=0.6u W=0.365u nf=1 ad=1.825e-13 as=1.825e-13 pd=1.73e-06
+ ps=1.73e-06 nrd=0 nrs=0 sa=0 sb=0 sd=0 m=1
XM_i_3 net2 A2 0 0 nfet_05v0 L=0.6u W=0.365u nf=1 ad=1.825e-13 as=1.825e-13 pd=1.73e-06 ps=1.73e-06
+ nrd=0 nrs=0 sa=0 sb=0 sd=0 m=1
XM_i_0 Z net1 0 0 nfet_05v0 L=0.6u W=0.815u nf=1 ad=4.075e-13 as=4.075e-13 pd=2.63e-06 ps=2.63e-06
+ nrd=0 nrs=0 sa=0 sb=0 sd=0 m=1
XM_i_4 net1 A1 VDD VDD pfet_05v0 L=0.5u W=0.6u nf=1 ad=3e-13 as=3e-13 pd=2.2e-06 ps=2.2e-06 nrd=0
+ nrs=0 sa=0 sb=0 sd=0 m=1
XM_i_5 net1 A2 VDD VDD pfet_05v0 L=0.5u W=0.6u nf=1 ad=3e-13 as=3e-13 pd=2.2e-06 ps=2.2e-06 nrd=0
+ nrs=0 sa=0 sb=0 sd=0 m=1
XM_i_1 Z net1 VDD VDD pfet_05v0 L=0.5u W=1.215u nf=1 ad=6.075e-13 as=6.075e-13 pd=3.43e-06
+ ps=3.43e-06 nrd=0 nrs=0 sa=0 sb=0 sd=0 m=1
.ends

* expanding   symbol:  ~/metastability-298/build/sims/kit/cells_tx/xor2_1.sym # of pins=3
** sym_path: ~/metastability-298/build/sims/kit/cells_tx/xor2_1.sym
** sch_path: ~/metastability-298/build/sims/kit/cells_tx/xor2_1.sch
.subckt xor2_1 A1 A2 Z
*.ipin A1
*.ipin A2
*.opin Z
XM_i_6 net1 A2 0 0 nfet_05v0 L=0.6u W=0.36u nf=1 ad=1.8e-13 as=1.8e-13 pd=1.72e-06 ps=1.72e-06 nrd=0
+ nrs=0 sa=0 sb=0 sd=0 m=1
XM_i_7 net1 A1 0 0 nfet_05v0 L=0.6u W=0.36u nf=1 ad=1.8e-13 as=1.8e-13 pd=1.72e-06 ps=1.72e-06 nrd=0
+ nrs=0 sa=0 sb=0 sd=0 m=1
XM_i_2 Z net1 0 0 nfet_05v0 L=0.6u W=0.82u nf=1 ad=4.1e-13 as=4.1e-13 pd=2.64e-06 ps=2.64e-06 nrd=0
+ nrs=0 sa=0 sb=0 sd=0 m=1
XM_i_0 net3 A1 Z 0 nfet_05v0 L=0.6u W=0.82u nf=1 ad=4.1e-13 as=4.1e-13 pd=2.64e-06 ps=2.64e-06 nrd=0
+ nrs=0 sa=0 sb=0 sd=0 m=1
XM_i_1 net3 A2 0 0 nfet_05v0 L=0.6u W=0.82u nf=1 ad=4.1e-13 as=4.1e-13 pd=2.64e-06 ps=2.64e-06 nrd=0
+ nrs=0 sa=0 sb=0 sd=0 m=1
XM_i_8 net1 A2 net4 VDD pfet_05v0 L=0.5u W=0.56u nf=1 ad=2.8e-13 as=2.8e-13 pd=2.12e-06 ps=2.12e-06
+ nrd=0 nrs=0 sa=0 sb=0 sd=0 m=1
XM_i_9 net4 A1 VDD VDD pfet_05v0 L=0.5u W=0.56u nf=1 ad=2.8e-13 as=2.8e-13 pd=2.12e-06 ps=2.12e-06
+ nrd=0 nrs=0 sa=0 sb=0 sd=0 m=1
XM_i_5 net2 net1 VDD VDD pfet_05v0 L=0.5u W=1.22u nf=1 ad=6.1e-13 as=6.1e-13 pd=3.44e-06 ps=3.44e-06
+ nrd=0 nrs=0 sa=0 sb=0 sd=0 m=1
XM_i_3 Z A1 net2 VDD pfet_05v0 L=0.5u W=1.22u nf=1 ad=6.1e-13 as=6.1e-13 pd=3.44e-06 ps=3.44e-06
+ nrd=0 nrs=0 sa=0 sb=0 sd=0 m=1
XM_i_4 Z A2 net2 VDD pfet_05v0 L=0.5u W=1.22u nf=1 ad=6.1e-13 as=6.1e-13 pd=3.44e-06 ps=3.44e-06
+ nrd=0 nrs=0 sa=0 sb=0 sd=0 m=1
.ends

* expanding   symbol:  ~/metastability-298/build/sims/kit/cells_tx/dffnq_1.sym # of pins=3
** sym_path: ~/metastability-298/build/sims/kit/cells_tx/dffnq_1.sym
** sch_path: ~/metastability-298/build/sims/kit/cells_tx/dffnq_1.sch
.subckt dffnq_1 D CLKN Q
*.ipin D
*.ipin CLKN
*.opin Q
XM_tn9 net1 CLKN 0 0 nfet_05v0 L=0.6u W=0.465u nf=1 ad=2.325e-13 as=2.325e-13 pd=1.93e-06
+ ps=1.93e-06 nrd=0 nrs=0 sa=0 sb=0 sd=0 m=1
XM_tn16 net2 net1 0 0 nfet_05v0 L=0.6u W=0.465u nf=1 ad=2.325e-13 as=2.325e-13 pd=1.93e-06
+ ps=1.93e-06 nrd=0 nrs=0 sa=0 sb=0 sd=0 m=1
XM_tn10 net7 D 0 0 nfet_05v0 L=0.6u W=0.36u nf=1 ad=1.8e-13 as=1.8e-13 pd=1.72e-06 ps=1.72e-06 nrd=0
+ nrs=0 sa=0 sb=0 sd=0 m=1
XM_tn11 net4 net2 net7 0 nfet_05v0 L=0.6u W=0.36u nf=1 ad=1.8e-13 as=1.8e-13 pd=1.72e-06 ps=1.72e-06
+ nrd=0 nrs=0 sa=0 sb=0 sd=0 m=1
XM_tn0 net4 net1 net9 0 nfet_05v0 L=0.6u W=0.36u nf=1 ad=1.8e-13 as=1.8e-13 pd=1.72e-06 ps=1.72e-06
+ nrd=0 nrs=0 sa=0 sb=0 sd=0 m=1
XM_tn1 net9 net6 0 0 nfet_05v0 L=0.6u W=0.36u nf=1 ad=1.8e-13 as=1.8e-13 pd=1.72e-06 ps=1.72e-06
+ nrd=0 nrs=0 sa=0 sb=0 sd=0 m=1
XM_tn15 net6 net4 0 0 nfet_05v0 L=0.6u W=0.36u nf=1 ad=1.8e-13 as=1.8e-13 pd=1.72e-06 ps=1.72e-06
+ nrd=0 nrs=0 sa=0 sb=0 sd=0 m=1
XM_tn2 net5 net1 net6 0 nfet_05v0 L=0.6u W=0.36u nf=1 ad=1.8e-13 as=1.8e-13 pd=1.72e-06 ps=1.72e-06
+ nrd=0 nrs=0 sa=0 sb=0 sd=0 m=1
XM_tn3 net5 net2 net8 0 nfet_05v0 L=0.6u W=0.36u nf=1 ad=1.8e-13 as=1.8e-13 pd=1.72e-06 ps=1.72e-06
+ nrd=0 nrs=0 sa=0 sb=0 sd=0 m=1
XM_tn4 net8 net3 0 0 nfet_05v0 L=0.6u W=0.63u nf=1 ad=3.15e-13 as=3.15e-13 pd=2.26e-06 ps=2.26e-06
+ nrd=0 nrs=0 sa=0 sb=0 sd=0 m=1
XM_tn5 net3 net5 0 0 nfet_05v0 L=0.6u W=0.63u nf=1 ad=3.15e-13 as=3.15e-13 pd=2.26e-06 ps=2.26e-06
+ nrd=0 nrs=0 sa=0 sb=0 sd=0 m=1
XM_tn6 Q net3 0 0 nfet_05v0 L=0.6u W=0.82u nf=1 ad=4.1e-13 as=4.1e-13 pd=2.64e-06 ps=2.64e-06 nrd=0
+ nrs=0 sa=0 sb=0 sd=0 m=1
XM_tp9 net1 CLKN VDD VDD pfet_05v0 L=0.5u W=0.865u nf=1 ad=4.325e-13 as=4.325e-13 pd=2.73e-06
+ ps=2.73e-06 nrd=0 nrs=0 sa=0 sb=0 sd=0 m=1
XM_tp16 net2 net1 VDD VDD pfet_05v0 L=0.5u W=0.865u nf=1 ad=4.325e-13 as=4.325e-13 pd=2.73e-06
+ ps=2.73e-06 nrd=0 nrs=0 sa=0 sb=0 sd=0 m=1
XM_tp10 net7 D VDD VDD pfet_05v0 L=0.5u W=0.495u nf=1 ad=2.475e-13 as=2.475e-13 pd=1.99e-06
+ ps=1.99e-06 nrd=0 nrs=0 sa=0 sb=0 sd=0 m=1
XM_tp11 net4 net1 net7 VDD pfet_05v0 L=0.5u W=0.495u nf=1 ad=2.475e-13 as=2.475e-13 pd=1.99e-06
+ ps=1.99e-06 nrd=0 nrs=0 sa=0 sb=0 sd=0 m=1
XM_tp0 net4 net2 net10 VDD pfet_05v0 L=0.5u W=0.495u nf=1 ad=2.475e-13 as=2.475e-13 pd=1.99e-06
+ ps=1.99e-06 nrd=0 nrs=0 sa=0 sb=0 sd=0 m=1
XM_tp1 net10 net6 VDD VDD pfet_05v0 L=0.5u W=0.495u nf=1 ad=2.475e-13 as=2.475e-13 pd=1.99e-06
+ ps=1.99e-06 nrd=0 nrs=0 sa=0 sb=0 sd=0 m=1
XM_tp15 net6 net4 VDD VDD pfet_05v0 L=0.5u W=0.495u nf=1 ad=2.475e-13 as=2.475e-13 pd=1.99e-06
+ ps=1.99e-06 nrd=0 nrs=0 sa=0 sb=0 sd=0 m=1
XM_tp7 net5 net2 net6 VDD pfet_05v0 L=0.5u W=0.495u nf=1 ad=2.475e-13 as=2.475e-13 pd=1.99e-06
+ ps=1.99e-06 nrd=0 nrs=0 sa=0 sb=0 sd=0 m=1
XM_tp6 net5 net1 net8 VDD pfet_05v0 L=0.5u W=0.495u nf=1 ad=2.475e-13 as=2.475e-13 pd=1.99e-06
+ ps=1.99e-06 nrd=0 nrs=0 sa=0 sb=0 sd=0 m=1
XM_tp2 net8 net3 VDD VDD pfet_05v0 L=0.5u W=1.075u nf=1 ad=5.375e-13 as=5.375e-13 pd=3.15e-06
+ ps=3.15e-06 nrd=0 nrs=0 sa=0 sb=0 sd=0 m=1
XM_tp3 net3 net5 VDD VDD pfet_05v0 L=0.5u W=1.075u nf=1 ad=5.375e-13 as=5.375e-13 pd=3.15e-06
+ ps=3.15e-06 nrd=0 nrs=0 sa=0 sb=0 sd=0 m=1
XM_tp4 Q net3 VDD VDD pfet_05v0 L=0.5u W=1.13u nf=1 ad=5.65e-13 as=5.65e-13 pd=3.26e-06 ps=3.26e-06
+ nrd=0 nrs=0 sa=0 sb=0 sd=0 m=1
.ends

* expanding   symbol:  ~/metastability-298/build/sims/kit/cells_tx/dffnrnq_1.sym # of
*+ pins=4
** sym_path: ~/metastability-298/build/sims/kit/cells_tx/dffnrnq_1.sym
** sch_path: ~/metastability-298/build/sims/kit/cells_tx/dffnrnq_1.sch
.subckt dffnrnq_1 D RN CLKN Q
*.ipin D
*.ipin RN
*.ipin CLKN
*.opin Q
XM_tn13 net1 CLKN 0 0 nfet_05v0 L=0.6u W=0.405u nf=1 ad=2.025e-13 as=2.025e-13 pd=1.81e-06
+ ps=1.81e-06 nrd=0 nrs=0 sa=0 sb=0 sd=0 m=1
XM_tn10 net3 net1 0 0 nfet_05v0 L=0.6u W=0.405u nf=1 ad=2.025e-13 as=2.025e-13 pd=1.81e-06
+ ps=1.81e-06 nrd=0 nrs=0 sa=0 sb=0 sd=0 m=1
XM_tn11 net7 D 0 0 nfet_05v0 L=0.6u W=0.39u nf=1 ad=1.95e-13 as=1.95e-13 pd=1.78e-06 ps=1.78e-06
+ nrd=0 nrs=0 sa=0 sb=0 sd=0 m=1
XM_tn15 net4 net3 net7 0 nfet_05v0 L=0.6u W=0.39u nf=1 ad=1.95e-13 as=1.95e-13 pd=1.78e-06
+ ps=1.78e-06 nrd=0 nrs=0 sa=0 sb=0 sd=0 m=1
XM_tn14 net4 net1 net10 0 nfet_05v0 L=0.6u W=0.39u nf=1 ad=1.95e-13 as=1.95e-13 pd=1.78e-06
+ ps=1.78e-06 nrd=0 nrs=0 sa=0 sb=0 sd=0 m=1
XM_tn8 net10 net5 net11 0 nfet_05v0 L=0.6u W=0.39u nf=1 ad=1.95e-13 as=1.95e-13 pd=1.78e-06
+ ps=1.78e-06 nrd=0 nrs=0 sa=0 sb=0 sd=0 m=1
XM_tn9 net11 RN 0 0 nfet_05v0 L=0.6u W=0.39u nf=1 ad=1.95e-13 as=1.95e-13 pd=1.78e-06 ps=1.78e-06
+ nrd=0 nrs=0 sa=0 sb=0 sd=0 m=1
XM_tn18 net5 net4 0 0 nfet_05v0 L=0.6u W=0.39u nf=1 ad=1.95e-13 as=1.95e-13 pd=1.78e-06 ps=1.78e-06
+ nrd=0 nrs=0 sa=0 sb=0 sd=0 m=1
XM_tn0 net6 net1 net5 0 nfet_05v0 L=0.6u W=0.39u nf=1 ad=1.95e-13 as=1.95e-13 pd=1.78e-06
+ ps=1.78e-06 nrd=0 nrs=0 sa=0 sb=0 sd=0 m=1
XM_tn1 net6 net3 net8 0 nfet_05v0 L=0.6u W=0.39u nf=1 ad=1.95e-13 as=1.95e-13 pd=1.78e-06
+ ps=1.78e-06 nrd=0 nrs=0 sa=0 sb=0 sd=0 m=1
XM_tn12 net8 net2 0 0 nfet_05v0 L=0.6u W=0.39u nf=1 ad=1.95e-13 as=1.95e-13 pd=1.78e-06 ps=1.78e-06
+ nrd=0 nrs=0 sa=0 sb=0 sd=0 m=1
XM_tn5 net12 RN 0 0 nfet_05v0 L=0.6u W=0.39u nf=1 ad=1.95e-13 as=1.95e-13 pd=1.78e-06 ps=1.78e-06
+ nrd=0 nrs=0 sa=0 sb=0 sd=0 m=1
XM_tn4 net2 net6 net12 0 nfet_05v0 L=0.6u W=0.4u nf=1 ad=2e-13 as=2e-13 pd=1.8e-06 ps=1.8e-06 nrd=0
+ nrs=0 sa=0 sb=0 sd=0 m=1
XM_tn3 Q net2 0 0 nfet_05v0 L=0.6u W=0.795u nf=1 ad=3.975e-13 as=3.975e-13 pd=2.59e-06 ps=2.59e-06
+ nrd=0 nrs=0 sa=0 sb=0 sd=0 m=1
XM_tp11 net1 CLKN VDD VDD pfet_05v0 L=0.5u W=0.865u nf=1 ad=4.325e-13 as=4.325e-13 pd=2.73e-06
+ ps=2.73e-06 nrd=0 nrs=0 sa=0 sb=0 sd=0 m=1
XM_tp8 net3 net1 VDD VDD pfet_05v0 L=0.5u W=0.865u nf=1 ad=4.325e-13 as=4.325e-13 pd=2.73e-06
+ ps=2.73e-06 nrd=0 nrs=0 sa=0 sb=0 sd=0 m=1
XM_tp9 net7 D VDD VDD pfet_05v0 L=0.5u W=0.76u nf=1 ad=3.8e-13 as=3.8e-13 pd=2.52e-06 ps=2.52e-06
+ nrd=0 nrs=0 sa=0 sb=0 sd=0 m=1
XM_tp15 net4 net1 net7 VDD pfet_05v0 L=0.5u W=0.76u nf=1 ad=3.8e-13 as=3.8e-13 pd=2.52e-06
+ ps=2.52e-06 nrd=0 nrs=0 sa=0 sb=0 sd=0 m=1
XM_tp7 net4 net3 net9 VDD pfet_05v0 L=0.5u W=0.76u nf=1 ad=3.8e-13 as=3.8e-13 pd=2.52e-06
+ ps=2.52e-06 nrd=0 nrs=0 sa=0 sb=0 sd=0 m=1
XM_tp6 net9 net5 VDD VDD pfet_05v0 L=0.5u W=0.76u nf=1 ad=3.8e-13 as=3.8e-13 pd=2.52e-06 ps=2.52e-06
+ nrd=0 nrs=0 sa=0 sb=0 sd=0 m=1
XM_tp12 net9 RN VDD VDD pfet_05v0 L=0.5u W=0.76u nf=1 ad=3.8e-13 as=3.8e-13 pd=2.52e-06 ps=2.52e-06
+ nrd=0 nrs=0 sa=0 sb=0 sd=0 m=1
XM_tp18 net5 net4 VDD VDD pfet_05v0 L=0.5u W=0.505u nf=1 ad=2.525e-13 as=2.525e-13 pd=2.01e-06
+ ps=2.01e-06 nrd=0 nrs=0 sa=0 sb=0 sd=0 m=1
XM_tp2 net6 net3 net5 VDD pfet_05v0 L=0.5u W=0.505u nf=1 ad=2.525e-13 as=2.525e-13 pd=2.01e-06
+ ps=2.01e-06 nrd=0 nrs=0 sa=0 sb=0 sd=0 m=1
XM_tp3 net6 net1 net8 VDD pfet_05v0 L=0.5u W=0.505u nf=1 ad=2.525e-13 as=2.525e-13 pd=2.01e-06
+ ps=2.01e-06 nrd=0 nrs=0 sa=0 sb=0 sd=0 m=1
XM_tp10 net8 net2 VDD VDD pfet_05v0 L=0.5u W=0.505u nf=1 ad=2.525e-13 as=2.525e-13 pd=2.01e-06
+ ps=2.01e-06 nrd=0 nrs=0 sa=0 sb=0 sd=0 m=1
XM_tp5 net2 RN VDD VDD pfet_05v0 L=0.5u W=0.94u nf=1 ad=4.7e-13 as=4.7e-13 pd=2.88e-06 ps=2.88e-06
+ nrd=0 nrs=0 sa=0 sb=0 sd=0 m=1
XM_tp4 net2 net6 VDD VDD pfet_05v0 L=0.5u W=0.94u nf=1 ad=4.7e-13 as=4.7e-13 pd=2.88e-06 ps=2.88e-06
+ nrd=0 nrs=0 sa=0 sb=0 sd=0 m=1
XM_tp1 Q net2 VDD VDD pfet_05v0 L=0.5u W=1.175u nf=1 ad=5.875e-13 as=5.875e-13 pd=3.35e-06
+ ps=3.35e-06 nrd=0 nrs=0 sa=0 sb=0 sd=0 m=1
.ends

* expanding   symbol:  ~/metastability-298/build/sims/kit/cells_tx/nand2_1.sym # of pins=3
** sym_path: ~/metastability-298/build/sims/kit/cells_tx/nand2_1.sym
** sch_path: ~/metastability-298/build/sims/kit/cells_tx/nand2_1.sch
.subckt nand2_1 A1 A2 ZN
*.ipin A1
*.ipin A2
*.opin ZN
XM_i_1 net1 A2 0 0 nfet_05v0 L=0.6u W=0.82u nf=1 ad=4.1e-13 as=4.1e-13 pd=2.64e-06 ps=2.64e-06 nrd=0
+ nrs=0 sa=0 sb=0 sd=0 m=1
XM_i_0 ZN A1 net1 0 nfet_05v0 L=0.6u W=0.82u nf=1 ad=4.1e-13 as=4.1e-13 pd=2.64e-06 ps=2.64e-06
+ nrd=0 nrs=0 sa=0 sb=0 sd=0 m=1
XM_i_3 ZN A2 VDD VDD pfet_05v0 L=0.5u W=1.13u nf=1 ad=5.65e-13 as=5.65e-13 pd=3.26e-06 ps=3.26e-06
+ nrd=0 nrs=0 sa=0 sb=0 sd=0 m=1
XM_i_2 ZN A1 VDD VDD pfet_05v0 L=0.5u W=1.13u nf=1 ad=5.65e-13 as=5.65e-13 pd=3.26e-06 ps=3.26e-06
+ nrd=0 nrs=0 sa=0 sb=0 sd=0 m=1
.ends

* expanding   symbol:  ~/metastability-298/build/sims/kit/cells_tx/or2_1.sym # of pins=3
** sym_path: ~/metastability-298/build/sims/kit/cells_tx/or2_1.sym
** sch_path: ~/metastability-298/build/sims/kit/cells_tx/or2_1.sch
.subckt or2_1 A1 A2 Z
*.ipin A1
*.ipin A2
*.opin Z
XM_i_2 net1 A1 0 0 nfet_05v0 L=0.6u W=0.36u nf=1 ad=1.8e-13 as=1.8e-13 pd=1.72e-06 ps=1.72e-06 nrd=0
+ nrs=0 sa=0 sb=0 sd=0 m=1
XM_i_3 net1 A2 0 0 nfet_05v0 L=0.6u W=0.36u nf=1 ad=1.8e-13 as=1.8e-13 pd=1.72e-06 ps=1.72e-06 nrd=0
+ nrs=0 sa=0 sb=0 sd=0 m=1
XM_i_0 Z net1 0 0 nfet_05v0 L=0.6u W=0.82u nf=1 ad=4.1e-13 as=4.1e-13 pd=2.64e-06 ps=2.64e-06 nrd=0
+ nrs=0 sa=0 sb=0 sd=0 m=1
XM_i_4 net1 A1 net2 VDD pfet_05v0 L=0.5u W=0.565u nf=1 ad=2.825e-13 as=2.825e-13 pd=2.13e-06
+ ps=2.13e-06 nrd=0 nrs=0 sa=0 sb=0 sd=0 m=1
XM_i_5 net2 A2 VDD VDD pfet_05v0 L=0.5u W=0.565u nf=1 ad=2.825e-13 as=2.825e-13 pd=2.13e-06
+ ps=2.13e-06 nrd=0 nrs=0 sa=0 sb=0 sd=0 m=1
XM_i_1 Z net1 VDD VDD pfet_05v0 L=0.5u W=1.22u nf=1 ad=6.1e-13 as=6.1e-13 pd=3.44e-06 ps=3.44e-06
+ nrd=0 nrs=0 sa=0 sb=0 sd=0 m=1
.ends

* expanding   symbol:  ~/metastability-298/build/sims/kit/cells_tx/mux2_1.sym # of pins=4
** sym_path: ~/metastability-298/build/sims/kit/cells_tx/mux2_1.sym
** sch_path: ~/metastability-298/build/sims/kit/cells_tx/mux2_1.sch
.subckt mux2_1 I0 I1 S Z
*.ipin I0
*.ipin I1
*.ipin S
*.opin Z
XM_MN2 Z net1 0 0 nfet_05v0 L=0.6u W=0.82u nf=1 ad=4.1e-13 as=4.1e-13 pd=2.64e-06 ps=2.64e-06 nrd=0
+ nrs=0 sa=0 sb=0 sd=0 m=1
XM_MN4 net3 I1 0 0 nfet_05v0 L=0.6u W=0.36u nf=1 ad=1.8e-13 as=1.8e-13 pd=1.72e-06 ps=1.72e-06 nrd=0
+ nrs=0 sa=0 sb=0 sd=0 m=1
XM_MN8 net1 S net3 0 nfet_05v0 L=0.6u W=0.36u nf=1 ad=1.8e-13 as=1.8e-13 pd=1.72e-06 ps=1.72e-06
+ nrd=0 nrs=0 sa=0 sb=0 sd=0 m=1
XM_MN7 net1 net2 net4 0 nfet_05v0 L=0.6u W=0.36u nf=1 ad=1.8e-13 as=1.8e-13 pd=1.72e-06 ps=1.72e-06
+ nrd=0 nrs=0 sa=0 sb=0 sd=0 m=1
XM_MN3 net4 I0 0 0 nfet_05v0 L=0.6u W=0.36u nf=1 ad=1.8e-13 as=1.8e-13 pd=1.72e-06 ps=1.72e-06 nrd=0
+ nrs=0 sa=0 sb=0 sd=0 m=1
XM_MN1 net2 S 0 0 nfet_05v0 L=0.6u W=0.36u nf=1 ad=1.8e-13 as=1.8e-13 pd=1.72e-06 ps=1.72e-06 nrd=0
+ nrs=0 sa=0 sb=0 sd=0 m=1
XM_MP5 Z net1 VDD VDD pfet_05v0 L=0.5u W=1.22u nf=1 ad=6.1e-13 as=6.1e-13 pd=3.44e-06 ps=3.44e-06
+ nrd=0 nrs=0 sa=0 sb=0 sd=0 m=1
XM_MP4 net5 I1 VDD VDD pfet_05v0 L=0.5u W=0.615u nf=1 ad=3.075e-13 as=3.075e-13 pd=2.23e-06
+ ps=2.23e-06 nrd=0 nrs=0 sa=0 sb=0 sd=0 m=1
XM_MP8 net1 net2 net5 VDD pfet_05v0 L=0.5u W=0.615u nf=1 ad=3.075e-13 as=3.075e-13 pd=2.23e-06
+ ps=2.23e-06 nrd=0 nrs=0 sa=0 sb=0 sd=0 m=1
XM_MP7 net1 S net6 VDD pfet_05v0 L=0.5u W=0.615u nf=1 ad=3.075e-13 as=3.075e-13 pd=2.23e-06
+ ps=2.23e-06 nrd=0 nrs=0 sa=0 sb=0 sd=0 m=1
XM_MP3 net6 I0 VDD VDD pfet_05v0 L=0.5u W=0.615u nf=1 ad=3.075e-13 as=3.075e-13 pd=2.23e-06
+ ps=2.23e-06 nrd=0 nrs=0 sa=0 sb=0 sd=0 m=1
XM_MP1 net2 S VDD VDD pfet_05v0 L=0.5u W=0.615u nf=1 ad=3.075e-13 as=3.075e-13 pd=2.23e-06
+ ps=2.23e-06 nrd=0 nrs=0 sa=0 sb=0 sd=0 m=1
.ends

.GLOBAL GND
.GLOBAL VDD
.end
