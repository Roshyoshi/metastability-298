* whole tile, flat extraction with wire and supply resistance (Magic 8.3.573 extresist), stimulus of make_tb_chip.py --data toggle
.include /usr/local/share/pdk/gf180mcuD/libs.tech/ngspice/design.ngspice
.lib /usr/local/share/pdk/gf180mcuD/libs.tech/ngspice/sm141064.ngspice typical
.lib /usr/local/share/pdk/gf180mcuD/libs.tech/ngspice/sm141064.ngspice diode_typical
.param sw_stat_global=0 sw_stat_mismatch=0
.temp 27.0
.include net_rc.spice   ; written by rc_extract.tcl
VDD VDPWR 0 3.3
VGS VGND 0 0
VCLK clk 0 PULSE(0 3.3 24.5n 0.1n 0.1n 24.9n 50n)
VRST rst_n 0 PWL(0 0 100n 0 100.1n 3.3)
VENA ena 0 3.3
VSTART ui_in[4] 0 PWL(0 0 300n 0 300.1n 3.3)
VCFG0 ui_in[3] 0 3.3
VCFG1 uio_in[6] 0 0
VDATA ui_in[6] 0 PULSE(0 3.3 75n 0.1n 0.1n 199.9n 400n)
VBIAS ua[0] 0 1.8
Vui_in_0 ui_in[0] 0 0
Vui_in_1 ui_in[1] 0 0
Vui_in_2 ui_in[2] 0 0
Vui_in_5 ui_in[5] 0 0
Vui_in_7 ui_in[7] 0 0
Vuio_in_0 uio_in[0] 0 0
Vuio_in_1 uio_in[1] 0 0
Vuio_in_2 uio_in[2] 0 0
Vuio_in_3 uio_in[3] 0 0
Vuio_in_4 uio_in[4] 0 0
Vuio_in_5 uio_in[5] 0 0
Vuio_in_7 uio_in[7] 0 0
Cuio_oe_0 uio_oe[0] 0 0.2p
Cuio_oe_1 uio_oe[1] 0 0.2p
Cuio_oe_2 uio_oe[2] 0 0.2p
Cuio_oe_3 uio_oe[3] 0 0.2p
Cuio_oe_4 uio_oe[4] 0 0.2p
Cuio_oe_5 uio_oe[5] 0 0.2p
Cuio_oe_6 uio_oe[6] 0 0.2p
Cuio_oe_7 uio_oe[7] 0 0.2p
Cuio_out_0 uio_out[0] 0 0.2p
Cuio_out_1 uio_out[1] 0 0.2p
Cuio_out_2 uio_out[2] 0 0.2p
Cuio_out_3 uio_out[3] 0 0.2p
Cuio_out_4 uio_out[4] 0 0.2p
Cuio_out_5 uio_out[5] 0 0.2p
Cuio_out_6 uio_out[6] 0 0.2p
Cuio_out_7 uio_out[7] 0 0.2p
Cuo_out_0 uo_out[0] 0 0.2p
Cuo_out_1 uo_out[1] 0 0.2p
Cuo_out_2 uo_out[2] 0 0.2p
Cuo_out_3 uo_out[3] 0 0.2p
Cuo_out_4 uo_out[4] 0 0.2p
Cuo_out_5 uo_out[5] 0 0.2p
Cuo_out_6 uo_out[6] 0 0.2p
Cuo_out_7 uo_out[7] 0 0.2p
.options klu
.options rshunt=1e12
.save i(VDD) i(VGS) v(clk) v(ena) v(rst_n) v(ua[0]) v(ua[1]) v(ua[2]) v(ua[3]) v(ua[4])
.save v(ua[5]) v(ua[6]) v(ua[7]) v(ui_in[0]) v(ui_in[1]) v(ui_in[2]) v(ui_in[3]) v(ui_in[4]) v(ui_in[5]) v(ui_in[6])
.save v(ui_in[7]) v(uio_in[0]) v(uio_in[1]) v(uio_in[2]) v(uio_in[3]) v(uio_in[4]) v(uio_in[5]) v(uio_in[6]) v(uio_in[7]) v(uio_oe[0])
.save v(uio_oe[1]) v(uio_oe[2]) v(uio_oe[3]) v(uio_oe[4]) v(uio_oe[5]) v(uio_oe[6]) v(uio_oe[7]) v(uio_out[0]) v(uio_out[1]) v(uio_out[2])
.save v(uio_out[3]) v(uio_out[4]) v(uio_out[5]) v(uio_out[6]) v(uio_out[7]) v(uo_out[0]) v(uo_out[1]) v(uo_out[2]) v(uo_out[3]) v(uo_out[4])
.save v(uo_out[5]) v(uo_out[6]) v(uo_out[7]) v(VGND.t296) v(VGND.t297) v(VGND.t298) v(VGND.t299) v(VDPWR.t338) v(VDPWR.t339) v(VDPWR.t340)
.save v(VDPWR.t341) v(VGND.t1210) v(VGND.t1211) v(VGND.t1212) v(VGND.t1213) v(VDPWR.t1241) v(VDPWR.t1242) v(VDPWR.t1281) v(VDPWR.t1282) v(VGND.t1399)
.save v(VGND.t1400)
.control
set filetype=binary
set num_threads=1
tran 10p 1200n
let first_cap=-1
meas tran first_cap when v(uio_out[4])=1.65 rise=1
let r=first_cap*1e9
echo RESULT rc first_capture_ns $&r
let d1=-1
meas tran d1 trig v(uio_out[4]) val=1.65 rise=1 targ v(uio_out[5]) val=1.65 rise=1
let r=d1*1e12
echo RESULT rc monitor_delay_ps_trial1 $&r
let d2=-1
meas tran d2 trig v(uio_out[4]) val=1.65 rise=2 targ v(uio_out[5]) val=1.65 rise=2
let r=d2*1e12
echo RESULT rc monitor_delay_ps_trial2 $&r
let d3=-1
meas tran d3 trig v(uio_out[4]) val=1.65 rise=3 targ v(uio_out[5]) val=1.65 rise=3
let r=d3*1e12
echo RESULT rc monitor_delay_ps_trial3 $&r
meas tran busy find v(uio_out[1]) at=1190n
echo RESULT rc busy_V $&busy
meas tran done find v(uio_out[2]) at=1190n
echo RESULT rc done_V $&done
meas tran fault find v(uio_out[3]) at=1190n
echo RESULT rc fault_V $&fault
meas tran ev0 find v(uo_out[0]) at=1190n
meas tran ev1 find v(uo_out[1]) at=1190n
meas tran ev2 find v(uo_out[2]) at=1190n
meas tran ev3 find v(uo_out[3]) at=1190n
meas tran ev4 find v(uo_out[4]) at=1190n
meas tran ev5 find v(uo_out[5]) at=1190n
meas tran ev6 find v(uo_out[6]) at=1190n
meas tran ev7 find v(uo_out[7]) at=1190n
let ev=1*(ev0 gt 1.65)+2*(ev1 gt 1.65)+4*(ev2 gt 1.65)+8*(ev3 gt 1.65)+16*(ev4 gt 1.65)+32*(ev5 gt 1.65)+64*(ev6 gt 1.65)+128*(ev7 gt 1.65)
echo RESULT rc events $&ev
rusage totiter tranpoints trantime
write rc.raw
.endc
.end
