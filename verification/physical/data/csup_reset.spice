* whole-tile bench (post_core: typical, 3.3 V, 27.0 C), generated by make_tb_chip.py
.include /usr/local/share/pdk/gf180mcuD/libs.tech/ngspice/design.ngspice
.lib /usr/local/share/pdk/gf180mcuD/libs.tech/ngspice/sm141064.ngspice typical
.lib /usr/local/share/pdk/gf180mcuD/libs.tech/ngspice/sm141064.ngspice diode_typical
.param sw_stat_global=0 sw_stat_mismatch=0
.temp 27.0
.include /home/claude/work/build/e449/tt_um_metastability_characterizer_pex.spice
VDD vdpwr 0 DC 3.3 AC 1
VCLK clk 0 0
VRST rst_n 0 0
VENA ena 0 3.3
VSTART ui_in_4 0 0
VCFG0 ui_in_3 0 3.3
VCFG1 uio_in_6 0 0
VDATA ui_in_6 0 0
VBIAS ua_0 0 1.8
Vui_in_0 ui_in_0 0 0
Rua_1 ua_1 0 1G
Rua_2 ua_2 0 1G
Rua_3 ua_3 0 1G
Rua_4 ua_4 0 1G
Rua_5 ua_5 0 1G
Rua_6 ua_6 0 1G
Rua_7 ua_7 0 1G
Vui_in_1 ui_in_1 0 0
Vui_in_2 ui_in_2 0 0
Vui_in_5 ui_in_5 0 0
Vui_in_7 ui_in_7 0 0
Vuio_in_0 uio_in_0 0 0
Vuio_in_1 uio_in_1 0 0
Vuio_in_2 uio_in_2 0 0
Vuio_in_3 uio_in_3 0 0
Vuio_in_4 uio_in_4 0 0
Vuio_in_5 uio_in_5 0 0
Vuio_in_7 uio_in_7 0 0
XDUT clk ena rst_n ua_0 ui_in_0 ui_in_3 ui_in_4 ui_in_6 uio_in_6 uio_oe_0 uio_oe_1 uio_oe_2 uio_oe_3 uio_oe_4 uio_oe_5 uio_oe_6 uio_oe_7 uio_out_0 uio_out_1 uio_out_2 uio_out_3 uio_out_4 uio_out_5 uio_out_6 uio_out_7 uo_out_0 uo_out_1 uo_out_2 uo_out_3 uo_out_4 uo_out_5 uo_out_6 uo_out_7 ua_1 ua_2 ua_3 ua_4 ua_5 ua_6 ua_7 ui_in_1 ui_in_2 ui_in_5 ui_in_7 uio_in_0 uio_in_1 uio_in_2 uio_in_3 uio_in_4 uio_in_5 uio_in_7 vdpwr 0 tt_um_metastability_characterizer
* capture_local = xdut.gf180mcu_fd_sc_mcu7t5v0__inv_2_8/zn
Ep_capture_local p_capture_local 0 xdut.gf180mcu_fd_sc_mcu7t5v0__inv_2_8/zn 0 1
* early_clk = xdut.gf180mcu_fd_sc_mcu7t5v0__inv_2_5/zn
Ep_early_clk p_early_clk 0 xdut.gf180mcu_fd_sc_mcu7t5v0__inv_2_5/zn 0 1
* selected_q = xdut.gf180mcu_fd_sc_mcu7t5v0__mux4_1_1/z
Ep_selected_q p_selected_q 0 xdut.gf180mcu_fd_sc_mcu7t5v0__mux4_1_1/z 0 1
* bank_selected_q = xdut.gf180mcu_fd_sc_mcu7t5v0__mux4_1_0/z
Ep_bank_selected_q p_bank_selected_q 0 xdut.gf180mcu_fd_sc_mcu7t5v0__mux4_1_0/z 0 1
* bank_obs_clk = xdut.gf180mcu_fd_sc_mcu7t5v0__inv_2_0/zn
Ep_bank_obs_clk p_bank_obs_clk 0 xdut.gf180mcu_fd_sc_mcu7t5v0__inv_2_0/zn 0 1
* bank_early_q = xdut.gf180mcu_fd_sc_mcu7t5v0__dffq_1_0/q
Ep_bank_early_q p_bank_early_q 0 xdut.gf180mcu_fd_sc_mcu7t5v0__dffq_1_0/q 0 1
* bank_cap = xdut.meta_j3a_0/clk
Ep_bank_cap p_bank_cap 0 xdut.meta_j3a_0/clk 0 1
* b = xdut.gf180mcu_fd_sc_mcu7t5v0__dffq_1_2/d
Ep_b p_b 0 xdut.gf180mcu_fd_sc_mcu7t5v0__dffq_1_2/d 0 1
* allow_count = xdut.gf180mcu_fd_sc_mcu7t5v0__nand2_1_6/a2
Ep_allow_count p_allow_count 0 xdut.gf180mcu_fd_sc_mcu7t5v0__nand2_1_6/a2 0 1
* tick_n = xdut.gf180mcu_fd_sc_mcu7t5v0__nand2_1_6/zn
Ep_tick_n p_tick_n 0 xdut.gf180mcu_fd_sc_mcu7t5v0__nand2_1_6/zn 0 1
* run = xdut.gf180mcu_fd_sc_mcu7t5v0__and2_1_1/a1
Ep_run p_run 0 xdut.gf180mcu_fd_sc_mcu7t5v0__and2_1_1/a1 0 1
* n0 = xdut.gf180mcu_fd_sc_mcu7t5v0__inv_1_35/i
Ep_n0 p_n0 0 xdut.gf180mcu_fd_sc_mcu7t5v0__inv_1_35/i 0 1
* n1 = xdut.gf180mcu_fd_sc_mcu7t5v0__inv_1_34/i
Ep_n1 p_n1 0 xdut.gf180mcu_fd_sc_mcu7t5v0__inv_1_34/i 0 1
* n2 = xdut.gf180mcu_fd_sc_mcu7t5v0__inv_1_33/i
Ep_n2 p_n2 0 xdut.gf180mcu_fd_sc_mcu7t5v0__inv_1_33/i 0 1
* n3 = xdut.gf180mcu_fd_sc_mcu7t5v0__inv_1_32/i
Ep_n3 p_n3 0 xdut.gf180mcu_fd_sc_mcu7t5v0__inv_1_32/i 0 1
.options klu
.options rshunt=1e12
.control
op
print i(VDD)
ac dec 2 1e5 1e9
let c_pf = -imag(i(VDD))/(2*pi*frequency)*1e12
let g_us = -real(i(VDD))*1e6
print frequency c_pf g_us
.endc
.end
