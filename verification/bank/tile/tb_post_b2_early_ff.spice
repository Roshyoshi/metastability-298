* whole-tile bench (post_b2_early_ff: ff, 3.6 V, -40.0 C), generated by make_tb_chip.py
.include /usr/local/share/pdk/gf180mcuD/libs.tech/ngspice/design.ngspice
.lib /usr/local/share/pdk/gf180mcuD/libs.tech/ngspice/sm141064.ngspice ff
.lib /usr/local/share/pdk/gf180mcuD/libs.tech/ngspice/sm141064.ngspice diode_ff
.param sw_stat_global=0 sw_stat_mismatch=0
.temp -40.0
.include <extraction>/tt_um_metastability_characterizer_pex.spice
VDD vdpwr 0 3.6
VCLK clk 0 PULSE(0 3.6 24.5n 0.1n 0.1n 24.9n 50n)
VRST rst_n 0 PWL(0 0 100n 0 100.1n 3.6)
VENA ena 0 3.6
VSTART ui_in_4 0 PWL(0 0 300n 0 300.1n 3.6)
VCFG0 ui_in_3 0 3.6
VCFG1 uio_in_6 0 0
VDATA ui_in_6 0 3.6
VBIAS ua_0 0 1.8
VBANKEN ui_in_7 0 3.6
VBANKS0 ui_in_1 0 3.6
VBANKS1 ui_in_2 0 0
VBANKD uio_in_0 0 PULSE(0 3.6 75n 0.1n 0.1n 199.9n 400n)
VBANKOBS ui_in_5 0 PULSE(0 3.6 174.7n 0.1n 0.1n 50n 200n)
Vui_in_0 ui_in_0 0 0
Cuio_oe_0 uio_oe_0 0 0.2p
Cuio_oe_1 uio_oe_1 0 0.2p
Cuio_oe_2 uio_oe_2 0 0.2p
Cuio_oe_3 uio_oe_3 0 0.2p
Cuio_oe_4 uio_oe_4 0 0.2p
Cuio_oe_5 uio_oe_5 0 0.2p
Cuio_oe_6 uio_oe_6 0 0.2p
Cuio_oe_7 uio_oe_7 0 0.2p
Cuio_out_0 uio_out_0 0 0.2p
Cuio_out_1 uio_out_1 0 0.2p
Cuio_out_2 uio_out_2 0 0.2p
Cuio_out_3 uio_out_3 0 0.2p
Cuio_out_4 uio_out_4 0 0.2p
Cuio_out_5 uio_out_5 0 0.2p
Cuio_out_6 uio_out_6 0 0.2p
Cuio_out_7 uio_out_7 0 0.2p
Cuo_out_0 uo_out_0 0 0.2p
Cuo_out_1 uo_out_1 0 0.2p
Cuo_out_2 uo_out_2 0 0.2p
Cuo_out_3 uo_out_3 0 0.2p
Cuo_out_4 uo_out_4 0 0.2p
Cuo_out_5 uo_out_5 0 0.2p
Cuo_out_6 uo_out_6 0 0.2p
Cuo_out_7 uo_out_7 0 0.2p
Rua_1 ua_1 0 1G
Rua_2 ua_2 0 1G
Rua_3 ua_3 0 1G
Rua_4 ua_4 0 1G
Rua_5 ua_5 0 1G
Rua_6 ua_6 0 1G
Rua_7 ua_7 0 1G
Vuio_in_1 uio_in_1 0 0
Vuio_in_2 uio_in_2 0 0
Vuio_in_3 uio_in_3 0 0
Vuio_in_4 uio_in_4 0 0
Vuio_in_5 uio_in_5 0 0
Vuio_in_7 uio_in_7 0 0
XDUT clk ena rst_n ua_0 ui_in_0 ui_in_3 ui_in_4 ui_in_6 uio_in_6 uio_oe_0 uio_oe_1 uio_oe_2 uio_oe_3 uio_oe_4 uio_oe_5 uio_oe_6 uio_oe_7 uio_out_0 uio_out_1 uio_out_2 uio_out_3 uio_out_4 uio_out_5 uio_out_6 uio_out_7 uo_out_0 uo_out_1 uo_out_2 uo_out_3 uo_out_4 uo_out_5 uo_out_6 uo_out_7 ua_1 ua_2 ua_3 ua_4 ua_5 ua_6 ua_7 ui_in_1 ui_in_2 ui_in_5 ui_in_7 uio_in_0 uio_in_1 uio_in_2 uio_in_3 uio_in_4 uio_in_5 uio_in_7 vdpwr 0 tt_um_metastability_characterizer
* capture_local = xdut.gf180mcu_fd_sc_mcu7t5v0__inv_2_8/zn
Ep_capture_local p_capture_local 0 xdut.gf180mcu_fd_sc_mcu7t5v0__inv_2_8/zn 0 1
* early_clk = xdut.gf180mcu_fd_sc_mcu7t5v0__inv_2_5/zn
Ep_early_clk p_early_clk 0 xdut.gf180mcu_fd_sc_mcu7t5v0__inv_2_5/zn 0 1
* selected_q = xdut.gf180mcu_fd_sc_mcu7t5v0__mux4_1_1/z
Ep_selected_q p_selected_q 0 xdut.gf180mcu_fd_sc_mcu7t5v0__mux4_1_1/z 0 1
* bank_selected_q = xdut.gf180mcu_fd_sc_mcu7t5v0__mux4_1_0/z
Ep_bank_selected_q p_bank_selected_q 0 xdut.gf180mcu_fd_sc_mcu7t5v0__mux4_1_0/z 0 1
* bank_obs_clk = xdut.gf180mcu_fd_sc_mcu7t5v0__inv_2_0/zn
Ep_bank_obs_clk p_bank_obs_clk 0 xdut.gf180mcu_fd_sc_mcu7t5v0__inv_2_0/zn 0 1
* bank_early_q = xdut.gf180mcu_fd_sc_mcu7t5v0__dffq_1_0/q
Ep_bank_early_q p_bank_early_q 0 xdut.gf180mcu_fd_sc_mcu7t5v0__dffq_1_0/q 0 1
* bank_cap = xdut.meta_j3a_0/clk
Ep_bank_cap p_bank_cap 0 xdut.meta_j3a_0/clk 0 1
* b = xdut.gf180mcu_fd_sc_mcu7t5v0__dffq_1_2/d
Ep_b p_b 0 xdut.gf180mcu_fd_sc_mcu7t5v0__dffq_1_2/d 0 1
* allow_count = xdut.gf180mcu_fd_sc_mcu7t5v0__nand2_1_6/a2
Ep_allow_count p_allow_count 0 xdut.gf180mcu_fd_sc_mcu7t5v0__nand2_1_6/a2 0 1
* tick_n = xdut.gf180mcu_fd_sc_mcu7t5v0__nand2_1_6/zn
Ep_tick_n p_tick_n 0 xdut.gf180mcu_fd_sc_mcu7t5v0__nand2_1_6/zn 0 1
* run = xdut.gf180mcu_fd_sc_mcu7t5v0__and2_1_1/a1
Ep_run p_run 0 xdut.gf180mcu_fd_sc_mcu7t5v0__and2_1_1/a1 0 1
* n0 = xdut.gf180mcu_fd_sc_mcu7t5v0__inv_1_35/i
Ep_n0 p_n0 0 xdut.gf180mcu_fd_sc_mcu7t5v0__inv_1_35/i 0 1
* n1 = xdut.gf180mcu_fd_sc_mcu7t5v0__inv_1_34/i
Ep_n1 p_n1 0 xdut.gf180mcu_fd_sc_mcu7t5v0__inv_1_34/i 0 1
* n2 = xdut.gf180mcu_fd_sc_mcu7t5v0__inv_1_33/i
Ep_n2 p_n2 0 xdut.gf180mcu_fd_sc_mcu7t5v0__inv_1_33/i 0 1
* n3 = xdut.gf180mcu_fd_sc_mcu7t5v0__inv_1_32/i
Ep_n3 p_n3 0 xdut.gf180mcu_fd_sc_mcu7t5v0__inv_1_32/i 0 1
.options klu
.options rshunt=1e12
.control
set filetype=ascii
set num_threads=1
tran 10p 1600n
let first_cap=-1
meas tran first_cap when v(uio_out_4)=1.8 rise=1
if first_cap < 0
echo RESULT post_b2_early_ff first_capture_ns not_measured
else
let r=first_cap*1e9
echo RESULT post_b2_early_ff first_capture_ns $&r
end
let d1=-1
meas tran d1 trig v(uio_out_4) val=1.8 rise=1 targ v(uio_out_5) val=1.8 rise=1
if d1 < 0
echo RESULT post_b2_early_ff monitor_delay_ps_trial1 not_measured
else
let r=d1*1e12
echo RESULT post_b2_early_ff monitor_delay_ps_trial1 $&r
end
let d2=-1
meas tran d2 trig v(uio_out_4) val=1.8 rise=2 targ v(uio_out_5) val=1.8 rise=2
if d2 < 0
echo RESULT post_b2_early_ff monitor_delay_ps_trial2 not_measured
else
let r=d2*1e12
echo RESULT post_b2_early_ff monitor_delay_ps_trial2 $&r
end
let d3=-1
meas tran d3 trig v(uio_out_4) val=1.8 rise=3 targ v(uio_out_5) val=1.8 rise=3
if d3 < 0
echo RESULT post_b2_early_ff monitor_delay_ps_trial3 not_measured
else
let r=d3*1e12
echo RESULT post_b2_early_ff monitor_delay_ps_trial3 $&r
end
meas tran busy find v(uio_out_1) at=1590n
echo RESULT post_b2_early_ff busy_V $&busy
meas tran done find v(uio_out_2) at=1590n
echo RESULT post_b2_early_ff done_V $&done
meas tran fault find v(uio_out_3) at=1590n
echo RESULT post_b2_early_ff fault_V $&fault
meas tran ev0 find v(uo_out_0) at=1590n
meas tran ev1 find v(uo_out_1) at=1590n
meas tran ev2 find v(uo_out_2) at=1590n
meas tran ev3 find v(uo_out_3) at=1590n
meas tran ev4 find v(uo_out_4) at=1590n
meas tran ev5 find v(uo_out_5) at=1590n
meas tran ev6 find v(uo_out_6) at=1590n
meas tran ev7 find v(uo_out_7) at=1590n
let ev=1*(ev0 gt 1.8)+2*(ev1 gt 1.8)+4*(ev2 gt 1.8)+8*(ev3 gt 1.8)+16*(ev4 gt 1.8)+32*(ev5 gt 1.8)+64*(ev6 gt 1.8)+128*(ev7 gt 1.8)
echo RESULT post_b2_early_ff events $&ev
let d_trial1=-1
meas tran d_trial1 trig v(p_capture_local) val=1.8 rise=1 td=100n targ v(p_early_clk) val=1.8 rise=1 td=100n
if d_trial1 < 0
echo RESULT post_b2_early_ff d_trial1_ps not_measured
else
let r=d_trial1*1e12
echo RESULT post_b2_early_ff d_trial1_ps $&r
end
let d_trial2=-1
meas tran d_trial2 trig v(p_capture_local) val=1.8 rise=1 td=300n targ v(p_early_clk) val=1.8 rise=1 td=300n
if d_trial2 < 0
echo RESULT post_b2_early_ff d_trial2_ps not_measured
else
let r=d_trial2*1e12
echo RESULT post_b2_early_ff d_trial2_ps $&r
end
let d_trial3=-1
meas tran d_trial3 trig v(p_capture_local) val=1.8 rise=1 td=500n targ v(p_early_clk) val=1.8 rise=1 td=500n
if d_trial3 < 0
echo RESULT post_b2_early_ff d_trial3_ps not_measured
else
let r=d_trial3*1e12
echo RESULT post_b2_early_ff d_trial3_ps $&r
end
let bank_cap_after_capture_local_trial1=-1
meas tran bank_cap_after_capture_local_trial1 trig v(p_capture_local) val=1.8 rise=1 td=100n targ v(p_bank_cap) val=1.8 rise=1 td=100n
if bank_cap_after_capture_local_trial1 < 0
echo RESULT post_b2_early_ff bank_cap_after_capture_local_trial1_ps not_measured
else
let r=bank_cap_after_capture_local_trial1*1e12
echo RESULT post_b2_early_ff bank_cap_after_capture_local_trial1_ps $&r
end
let bank_cap_after_capture_local_trial2=-1
meas tran bank_cap_after_capture_local_trial2 trig v(p_capture_local) val=1.8 rise=1 td=300n targ v(p_bank_cap) val=1.8 rise=1 td=300n
if bank_cap_after_capture_local_trial2 < 0
echo RESULT post_b2_early_ff bank_cap_after_capture_local_trial2_ps not_measured
else
let r=bank_cap_after_capture_local_trial2*1e12
echo RESULT post_b2_early_ff bank_cap_after_capture_local_trial2_ps $&r
end
let bank_cap_after_capture_local_trial3=-1
meas tran bank_cap_after_capture_local_trial3 trig v(p_capture_local) val=1.8 rise=1 td=500n targ v(p_bank_cap) val=1.8 rise=1 td=500n
if bank_cap_after_capture_local_trial3 < 0
echo RESULT post_b2_early_ff bank_cap_after_capture_local_trial3_ps not_measured
else
let r=bank_cap_after_capture_local_trial3*1e12
echo RESULT post_b2_early_ff bank_cap_after_capture_local_trial3_ps $&r
end
let bank_q_arrives_falling=-1
meas tran bank_q_arrives_falling trig v(p_bank_cap) val=1.8 rise=1 td=300n targ v(p_bank_selected_q) val=1.8 fall=1 td=300n
if bank_q_arrives_falling < 0
echo RESULT post_b2_early_ff bank_q_arrives_falling_ps not_measured
else
let r=bank_q_arrives_falling*1e12
echo RESULT post_b2_early_ff bank_q_arrives_falling_ps $&r
end
let bank_q_arrives_rising=-1
meas tran bank_q_arrives_rising trig v(p_bank_cap) val=1.8 rise=1 td=500n targ v(p_bank_selected_q) val=1.8 rise=1 td=500n
if bank_q_arrives_rising < 0
echo RESULT post_b2_early_ff bank_q_arrives_rising_ps not_measured
else
let r=bank_q_arrives_rising*1e12
echo RESULT post_b2_early_ff bank_q_arrives_rising_ps $&r
end
let bank_obs_clk_after_bank_cap_trial2=-1
meas tran bank_obs_clk_after_bank_cap_trial2 trig v(p_bank_cap) val=1.8 rise=1 td=300n targ v(p_bank_obs_clk) val=1.8 rise=1 td=300n
if bank_obs_clk_after_bank_cap_trial2 < 0
echo RESULT post_b2_early_ff bank_obs_clk_after_bank_cap_trial2_ps not_measured
else
let r=bank_obs_clk_after_bank_cap_trial2*1e12
echo RESULT post_b2_early_ff bank_obs_clk_after_bank_cap_trial2_ps $&r
end
let run_edge=-1
meas tran run_edge trig v(p_run) val=0.36 rise=1 targ v(p_run) val=3.24 rise=1
if run_edge < 0
echo RESULT post_b2_early_ff run_edge_10_90_ps not_measured
else
let r=run_edge*1e12
echo RESULT post_b2_early_ff run_edge_10_90_ps $&r
end
meas tran tick_min min v(p_tick_n) from=700n to=900n
echo RESULT post_b2_early_ff tick_n_min_V_before_first_count $&tick_min
let b_fall_to_allow_count=-1
meas tran b_fall_to_allow_count trig v(p_b) val=1.8 fall=1 td=800n targ v(p_allow_count) val=1.8 rise=1
if b_fall_to_allow_count < 0
echo RESULT post_b2_early_ff b_fall_to_allow_count_ps not_measured
else
let r=b_fall_to_allow_count*1e12
echo RESULT post_b2_early_ff b_fall_to_allow_count_ps $&r
end
let b_rise_to_tick_n_fall=-1
meas tran b_rise_to_tick_n_fall trig v(p_b) val=1.8 rise=1 td=900n targ v(p_tick_n) val=1.8 fall=1
if b_rise_to_tick_n_fall < 0
echo RESULT post_b2_early_ff b_rise_to_tick_n_fall_ps not_measured
else
let r=b_rise_to_tick_n_fall*1e12
echo RESULT post_b2_early_ff b_rise_to_tick_n_fall_ps $&r
end
let tick_w=-1
meas tran tick_w trig v(p_tick_n) val=1.8 fall=1 targ v(p_tick_n) val=1.8 rise=1
if tick_w < 0
echo RESULT post_b2_early_ff count_pulse_width_ns not_measured
else
let r=tick_w*1e9
echo RESULT post_b2_early_ff count_pulse_width_ns $&r
end
let tick_n_to_n0=-1
meas tran tick_n_to_n0 trig v(p_tick_n) val=1.8 fall=1 targ v(p_n0) val=1.8 rise=1
if tick_n_to_n0 < 0
echo RESULT post_b2_early_ff tick_n_to_n0_ps not_measured
else
let r=tick_n_to_n0*1e12
echo RESULT post_b2_early_ff tick_n_to_n0_ps $&r
end
let n0_to_n1_through_inverter=-1
meas tran n0_to_n1_through_inverter trig v(p_n0) val=1.8 rise=1 targ v(p_n1) val=1.8 rise=1
if n0_to_n1_through_inverter < 0
echo RESULT post_b2_early_ff n0_to_n1_through_inverter_ps not_measured
else
let r=n0_to_n1_through_inverter*1e12
echo RESULT post_b2_early_ff n0_to_n1_through_inverter_ps $&r
end
let stage_n1_fall_to_n2_rise=-1
meas tran stage_n1_fall_to_n2_rise trig v(p_n1) val=1.8 fall=1 targ v(p_n2) val=1.8 rise=1
if stage_n1_fall_to_n2_rise < 0
echo RESULT post_b2_early_ff stage_n1_fall_to_n2_rise_ps not_measured
else
let r=stage_n1_fall_to_n2_rise*1e12
echo RESULT post_b2_early_ff stage_n1_fall_to_n2_rise_ps $&r
end
wrdata tb_chip_post_b2_early_ff.dat v(clk) v(uio_out_4) v(uio_out_5) v(uio_out_1) v(uo_out_0) v(uo_out_1) v(uo_out_2) v(uo_out_3) v(uo_out_4) v(uo_out_5) v(uo_out_6) v(uo_out_7) v(p_capture_local) v(p_early_clk) v(p_selected_q) v(p_bank_selected_q) v(p_bank_obs_clk) v(p_bank_early_q) v(p_bank_cap) v(p_b) v(p_allow_count) v(p_tick_n) v(p_run) v(p_n0) v(p_n1) v(p_n2) v(p_n3)
.endc
.end
