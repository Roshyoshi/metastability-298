* Master netlist: metastability characterizer, GF180MCU (gf180mcu_fd_sc_mcu7t5v0, operated at 3.3 V;
* the bank flip-flop N1 uses gf180mcu_as_sc_mcu7t3v3)
* Generated by tools/build_master.py. Do not edit by hand.
* Standard cells: and2_1, antenna, buf_1, dffnq_1, dffnrnq_1, dffq_1, dffrnq_1, inv_1, inv_12, inv_2, inv_4, mux2_1, mux4_1, nand2_1, nand2_2, nand2_4, or2_1, tiel, xor2_1
* 3.3 V cells: inv_2, nand2_2, nand2_4

.include ../pdk_cells/cdl/gf180mcu_as_sc_mcu7t3v3__inv_2.cdl
.include ../pdk_cells/cdl/gf180mcu_as_sc_mcu7t3v3__nand2_2.cdl
.include ../pdk_cells/cdl/gf180mcu_as_sc_mcu7t3v3__nand2_4.cdl
.include ../pdk_cells/cdl/gf180mcu_fd_sc_mcu7t5v0__and2_1.cdl
.include ../pdk_cells/cdl/gf180mcu_fd_sc_mcu7t5v0__antenna.cdl
.include ../pdk_cells/cdl/gf180mcu_fd_sc_mcu7t5v0__buf_1.cdl
.include ../pdk_cells/cdl/gf180mcu_fd_sc_mcu7t5v0__dffnq_1.cdl
.include ../pdk_cells/cdl/gf180mcu_fd_sc_mcu7t5v0__dffnrnq_1.cdl
.include ../pdk_cells/cdl/gf180mcu_fd_sc_mcu7t5v0__dffq_1.cdl
.include ../pdk_cells/cdl/gf180mcu_fd_sc_mcu7t5v0__dffrnq_1.cdl
.include ../pdk_cells/cdl/gf180mcu_fd_sc_mcu7t5v0__inv_1.cdl
.include ../pdk_cells/cdl/gf180mcu_fd_sc_mcu7t5v0__inv_12.cdl
.include ../pdk_cells/cdl/gf180mcu_fd_sc_mcu7t5v0__inv_2.cdl
.include ../pdk_cells/cdl/gf180mcu_fd_sc_mcu7t5v0__inv_4.cdl
.include ../pdk_cells/cdl/gf180mcu_fd_sc_mcu7t5v0__mux2_1.cdl
.include ../pdk_cells/cdl/gf180mcu_fd_sc_mcu7t5v0__mux4_1.cdl
.include ../pdk_cells/cdl/gf180mcu_fd_sc_mcu7t5v0__nand2_1.cdl
.include ../pdk_cells/cdl/gf180mcu_fd_sc_mcu7t5v0__nand2_2.cdl
.include ../pdk_cells/cdl/gf180mcu_fd_sc_mcu7t5v0__nand2_4.cdl
.include ../pdk_cells/cdl/gf180mcu_fd_sc_mcu7t5v0__or2_1.cdl
.include ../pdk_cells/cdl/gf180mcu_fd_sc_mcu7t5v0__tiel.cdl
.include ../pdk_cells/cdl/gf180mcu_fd_sc_mcu7t5v0__xor2_1.cdl

.SUBCKT meta_dut_baseline d clk q VDPWR VGND
Xu_cki clk clkn VDPWR VDPWR VGND VGND gf180mcu_fd_sc_mcu7t5v0__inv_1
Xu_mg1 d clkn g1 VDPWR VDPWR VGND VGND gf180mcu_fd_sc_mcu7t5v0__nand2_1
Xu_mg2 g1 clkn g2 VDPWR VDPWR VGND VGND gf180mcu_fd_sc_mcu7t5v0__nand2_1
Xu_mfw mqb g1 mq VDPWR VDPWR VGND VGND gf180mcu_fd_sc_mcu7t5v0__nand2_2
Xu_mkp mq g2 mqb VDPWR VDPWR VGND VGND gf180mcu_fd_sc_mcu7t5v0__nand2_1
Xu_sg1 mq clk s1 VDPWR VDPWR VGND VGND gf180mcu_fd_sc_mcu7t5v0__nand2_1
Xu_sg2 s1 clk s2 VDPWR VDPWR VGND VGND gf180mcu_fd_sc_mcu7t5v0__nand2_1
Xu_sfw sqb s1 q VDPWR VDPWR VGND VGND gf180mcu_fd_sc_mcu7t5v0__nand2_1
Xu_skp q s2 sqb VDPWR VDPWR VGND VGND gf180mcu_fd_sc_mcu7t5v0__nand2_1
.ENDS

.SUBCKT meta_dut_keeper d clk q VDPWR VGND
Xu_cki clk clkn VDPWR VDPWR VGND VGND gf180mcu_fd_sc_mcu7t5v0__inv_1
Xu_mg1 d clkn g1 VDPWR VDPWR VGND VGND gf180mcu_fd_sc_mcu7t5v0__nand2_1
Xu_mg2 g1 clkn g2 VDPWR VDPWR VGND VGND gf180mcu_fd_sc_mcu7t5v0__nand2_1
Xu_mfw mqb g1 mq VDPWR VDPWR VGND VGND gf180mcu_fd_sc_mcu7t5v0__nand2_2
Xu_mkp mq g2 mqb VDPWR VDPWR VGND VGND gf180mcu_fd_sc_mcu7t5v0__nand2_2
Xu_sg1 mq clk s1 VDPWR VDPWR VGND VGND gf180mcu_fd_sc_mcu7t5v0__nand2_1
Xu_sg2 s1 clk s2 VDPWR VDPWR VGND VGND gf180mcu_fd_sc_mcu7t5v0__nand2_1
Xu_sfw sqb s1 q VDPWR VDPWR VGND VGND gf180mcu_fd_sc_mcu7t5v0__nand2_1
Xu_skp q s2 sqb VDPWR VDPWR VGND VGND gf180mcu_fd_sc_mcu7t5v0__nand2_1
.ENDS

.SUBCKT meta_dut_forward d clk q VDPWR VGND
Xu_cki clk clkn VDPWR VDPWR VGND VGND gf180mcu_fd_sc_mcu7t5v0__inv_1
Xu_mg1 d clkn g1 VDPWR VDPWR VGND VGND gf180mcu_fd_sc_mcu7t5v0__nand2_1
Xu_mg2 g1 clkn g2 VDPWR VDPWR VGND VGND gf180mcu_fd_sc_mcu7t5v0__nand2_1
Xu_mfw mqb g1 mq VDPWR VDPWR VGND VGND gf180mcu_fd_sc_mcu7t5v0__nand2_4
Xu_mkp mq g2 mqb VDPWR VDPWR VGND VGND gf180mcu_fd_sc_mcu7t5v0__nand2_1
Xu_sg1 mq clk s1 VDPWR VDPWR VGND VGND gf180mcu_fd_sc_mcu7t5v0__nand2_1
Xu_sg2 s1 clk s2 VDPWR VDPWR VGND VGND gf180mcu_fd_sc_mcu7t5v0__nand2_1
Xu_sfw sqb s1 q VDPWR VDPWR VGND VGND gf180mcu_fd_sc_mcu7t5v0__nand2_1
Xu_skp q s2 sqb VDPWR VDPWR VGND VGND gf180mcu_fd_sc_mcu7t5v0__nand2_1
.ENDS

.SUBCKT meta_dut_n3ffb d clk q VDPWR VGND
Xu_cki VDPWR VDPWR VGND VGND clkn clk gf180mcu_as_sc_mcu7t3v3__inv_2
Xu_mg1 VDPWR VDPWR VGND VGND g1 d clkn gf180mcu_as_sc_mcu7t3v3__nand2_2
Xu_mg2 VDPWR VDPWR VGND VGND g2 g1 clkn gf180mcu_as_sc_mcu7t3v3__nand2_2
Xu_mfw VDPWR VDPWR VGND VGND mq g1 mqb gf180mcu_as_sc_mcu7t3v3__nand2_4
Xu_mkp VDPWR VDPWR VGND VGND mqb g2 mq gf180mcu_as_sc_mcu7t3v3__nand2_4
Xu_sg1 VDPWR VDPWR VGND VGND s1 mq clk gf180mcu_as_sc_mcu7t3v3__nand2_2
Xu_sg2 VDPWR VDPWR VGND VGND s2 s1 clk gf180mcu_as_sc_mcu7t3v3__nand2_2
Xu_sfw VDPWR VDPWR VGND VGND q sqb s1 gf180mcu_as_sc_mcu7t3v3__nand2_2
Xu_skp VDPWR VDPWR VGND VGND sqb q s2 gf180mcu_as_sc_mcu7t3v3__nand2_2
.ENDS

.SUBCKT meta_dut_j3a d clk q VDPWR VGND
Mckin_0 ckb clk VGND VGND nfet_03v3 W=1e-06 L=2.8e-07
Mckip_0 ckb clk VDPWR VDPWR pfet_03v3 W=1.38e-06 L=2.8e-07
Mdin_0 db d VGND VGND nfet_03v3 W=1e-06 L=2.8e-07
Mdip_0 db d VDPWR VDPWR pfet_03v3 W=1.38e-06 L=2.8e-07
Mmn1_0 x y VGND VGND nfet_03v3 W=1e-06 L=2.8e-07
Mmn1_1 x y VGND VGND nfet_03v3 W=1e-06 L=2.8e-07
Mmn1_2 x y VGND VGND nfet_03v3 W=1e-06 L=2.8e-07
Mmn1_3 x y VGND VGND nfet_03v3 W=1e-06 L=2.8e-07
Mmp1_0 x y VDPWR VDPWR pfet_03v3 W=1e-06 L=2.8e-07
Mmp1_1 x y VDPWR VDPWR pfet_03v3 W=1e-06 L=2.8e-07
Mmn2_0 y x VGND VGND nfet_03v3 W=1e-06 L=2.8e-07
Mmn2_1 y x VGND VGND nfet_03v3 W=1e-06 L=2.8e-07
Mmn2_2 y x VGND VGND nfet_03v3 W=1e-06 L=2.8e-07
Mmn2_3 y x VGND VGND nfet_03v3 W=1e-06 L=2.8e-07
Mmp2_0 y x VDPWR VDPWR pfet_03v3 W=1e-06 L=2.8e-07
Mmp2_1 y x VDPWR VDPWR pfet_03v3 W=1e-06 L=2.8e-07
Mmwx_0 x ckb ax VGND nfet_03v3 W=2e-06 L=2.8e-07
Mmdx_0 ax db VGND VGND nfet_03v3 W=4e-06 L=2.8e-07
Mmwy_0 y ckb ay VGND nfet_03v3 W=2e-06 L=2.8e-07
Mmdy_0 ay d VGND VGND nfet_03v3 W=4e-06 L=2.8e-07
Msn1_0 s sb VGND VGND nfet_03v3 W=5e-07 L=2.8e-07
Msp1_0 s sb VDPWR VDPWR pfet_03v3 W=3e-07 L=2.8e-07
Msn2_0 sb s VGND VGND nfet_03v3 W=5e-07 L=2.8e-07
Msp2_0 sb s VDPWR VDPWR pfet_03v3 W=3e-07 L=2.8e-07
Mswa_0 sb clk c1 VGND nfet_03v3 W=3e-07 L=2.8e-07
Msda_0 c1 x VGND VGND nfet_03v3 W=3e-07 L=2.8e-07
Mswb_0 s clk c2 VGND nfet_03v3 W=3e-07 L=2.8e-07
Msdb_0 c2 y VGND VGND nfet_03v3 W=3e-07 L=2.8e-07
Mqon_0 q sb VGND VGND nfet_03v3 W=1e-06 L=2.8e-07
Mqop_0 q sb VDPWR VDPWR pfet_03v3 W=1.38e-06 L=2.8e-07
Mqdn_0 qn s VGND VGND nfet_03v3 W=1e-06 L=2.8e-07
Mqdp_0 qn s VDPWR VDPWR pfet_03v3 W=1.38e-06 L=2.8e-07
.ENDS

.SUBCKT meta_delay_analog launch control sample_clk VDPWR VGND
* MP, MN, MC: current-starved inverter. MCT: timing capacitor (NMOS gate capacitor on node slow).
MMP slow launch VDPWR VDPWR pfet_05v0 W=1.22e-06 L=5e-07
MMN slow launch foot VGND nfet_05v0 W=8.2e-07 L=6e-07
MMC foot control VGND VGND nfet_05v0 W=3.6e-07 L=6e-07
MMCT VGND slow VGND VGND nfet_05v0 W=8.2e-07 L=1e-06
XXR0 slow r0 VDPWR VDPWR VGND VGND gf180mcu_fd_sc_mcu7t5v0__inv_1
XXR1 r0 r1 VDPWR VDPWR VGND VGND gf180mcu_fd_sc_mcu7t5v0__inv_2
XXR2 r1 sample_clk VDPWR VDPWR VGND VGND gf180mcu_fd_sc_mcu7t5v0__inv_2
.ENDS

.SUBCKT compact_control clk20 rst_n ena start q_selected early_e byte_sel capture busy done fault result_byte[0] result_byte[1] result_byte[2] result_byte[3] result_byte[4] result_byte[5] result_byte[6] result_byte[7] VDPWR VGND
Xa_ff b clk20 capture VDPWR VDPWR VGND VGND gf180mcu_fd_sc_mcu7t5v0__dffq_1
Xa_inv capture a_n VDPWR VDPWR VGND VGND gf180mcu_fd_sc_mcu7t5v0__inv_1
Xallow_ff want_count rst_n b allow_count VDPWR VDPWR VGND VGND gf180mcu_fd_sc_mcu7t5v0__dffnrnq_1
Xb_ff a_n rst_n clk20 b VDPWR VDPWR VGND VGND gf180mcu_fd_sc_mcu7t5v0__dffrnq_1
Xbad_xor l1 l2 bad_bit VDPWR VDPWR VGND VGND gf180mcu_fd_sc_mcu7t5v0__xor2_1
Xbusy_and run done_n busy VDPWR VDPWR VGND VGND gf180mcu_fd_sc_mcu7t5v0__and2_1
Xdone_ff n[16] run b done VDPWR VDPWR VGND VGND gf180mcu_fd_sc_mcu7t5v0__dffnrnq_1
Xdone_inv done done_n VDPWR VDPWR VGND VGND gf180mcu_fd_sc_mcu7t5v0__inv_1
Xevent_xor early_e l2 event_bit VDPWR VDPWR VGND VGND gf180mcu_fd_sc_mcu7t5v0__xor2_1
Xfault_ff fault_d run tick_n fault VDPWR VDPWR VGND VGND gf180mcu_fd_sc_mcu7t5v0__dffnrnq_1
Xfault_or fault bad_bit fault_d VDPWR VDPWR VGND VGND gf180mcu_fd_sc_mcu7t5v0__or2_1
Xfinished_inv n[16] finished_n VDPWR VDPWR VGND VGND gf180mcu_fd_sc_mcu7t5v0__inv_1
Xbyte0_mux k[0] k[8] byte_sel result_byte[0] VDPWR VDPWR VGND VGND gf180mcu_fd_sc_mcu7t5v0__mux2_1
Xbyte1_mux k[1] k[9] byte_sel result_byte[1] VDPWR VDPWR VGND VGND gf180mcu_fd_sc_mcu7t5v0__mux2_1
Xbyte2_mux k[2] k[10] byte_sel result_byte[2] VDPWR VDPWR VGND VGND gf180mcu_fd_sc_mcu7t5v0__mux2_1
Xbyte3_mux k[3] k[11] byte_sel result_byte[3] VDPWR VDPWR VGND VGND gf180mcu_fd_sc_mcu7t5v0__mux2_1
Xbyte4_mux k[4] k[12] byte_sel result_byte[4] VDPWR VDPWR VGND VGND gf180mcu_fd_sc_mcu7t5v0__mux2_1
Xbyte5_mux k[5] k[13] byte_sel result_byte[5] VDPWR VDPWR VGND VGND gf180mcu_fd_sc_mcu7t5v0__mux2_1
Xbyte6_mux k[6] k[14] byte_sel result_byte[6] VDPWR VDPWR VGND VGND gf180mcu_fd_sc_mcu7t5v0__mux2_1
Xbyte7_mux k[7] k[15] byte_sel result_byte[7] VDPWR VDPWR VGND VGND gf180mcu_fd_sc_mcu7t5v0__mux2_1
Xk10_ff k_n[10] run k[9] k[10] VDPWR VDPWR VGND VGND gf180mcu_fd_sc_mcu7t5v0__dffnrnq_1
Xk10_inv k[10] k_n[10] VDPWR VDPWR VGND VGND gf180mcu_fd_sc_mcu7t5v0__inv_1
Xk11_ff k_n[11] run k[10] k[11] VDPWR VDPWR VGND VGND gf180mcu_fd_sc_mcu7t5v0__dffnrnq_1
Xk11_inv k[11] k_n[11] VDPWR VDPWR VGND VGND gf180mcu_fd_sc_mcu7t5v0__inv_1
Xk12_ff k_n[12] run k[11] k[12] VDPWR VDPWR VGND VGND gf180mcu_fd_sc_mcu7t5v0__dffnrnq_1
Xk12_inv k[12] k_n[12] VDPWR VDPWR VGND VGND gf180mcu_fd_sc_mcu7t5v0__inv_1
Xk13_ff k_n[13] run k[12] k[13] VDPWR VDPWR VGND VGND gf180mcu_fd_sc_mcu7t5v0__dffnrnq_1
Xk13_inv k[13] k_n[13] VDPWR VDPWR VGND VGND gf180mcu_fd_sc_mcu7t5v0__inv_1
Xk14_ff k_n[14] run k[13] k[14] VDPWR VDPWR VGND VGND gf180mcu_fd_sc_mcu7t5v0__dffnrnq_1
Xk14_inv k[14] k_n[14] VDPWR VDPWR VGND VGND gf180mcu_fd_sc_mcu7t5v0__inv_1
Xk15_ff k_n[15] run k[14] k[15] VDPWR VDPWR VGND VGND gf180mcu_fd_sc_mcu7t5v0__dffnrnq_1
Xk15_inv k[15] k_n[15] VDPWR VDPWR VGND VGND gf180mcu_fd_sc_mcu7t5v0__inv_1
Xk1_ff k_n[1] run k[0] k[1] VDPWR VDPWR VGND VGND gf180mcu_fd_sc_mcu7t5v0__dffnrnq_1
Xk1_inv k[1] k_n[1] VDPWR VDPWR VGND VGND gf180mcu_fd_sc_mcu7t5v0__inv_1
Xk2_ff k_n[2] run k[1] k[2] VDPWR VDPWR VGND VGND gf180mcu_fd_sc_mcu7t5v0__dffnrnq_1
Xk2_inv k[2] k_n[2] VDPWR VDPWR VGND VGND gf180mcu_fd_sc_mcu7t5v0__inv_1
Xk3_ff k_n[3] run k[2] k[3] VDPWR VDPWR VGND VGND gf180mcu_fd_sc_mcu7t5v0__dffnrnq_1
Xk3_inv k[3] k_n[3] VDPWR VDPWR VGND VGND gf180mcu_fd_sc_mcu7t5v0__inv_1
Xk4_ff k_n[4] run k[3] k[4] VDPWR VDPWR VGND VGND gf180mcu_fd_sc_mcu7t5v0__dffnrnq_1
Xk4_inv k[4] k_n[4] VDPWR VDPWR VGND VGND gf180mcu_fd_sc_mcu7t5v0__inv_1
Xk5_ff k_n[5] run k[4] k[5] VDPWR VDPWR VGND VGND gf180mcu_fd_sc_mcu7t5v0__dffnrnq_1
Xk5_inv k[5] k_n[5] VDPWR VDPWR VGND VGND gf180mcu_fd_sc_mcu7t5v0__inv_1
Xk6_ff k_n[6] run k[5] k[6] VDPWR VDPWR VGND VGND gf180mcu_fd_sc_mcu7t5v0__dffnrnq_1
Xk6_inv k[6] k_n[6] VDPWR VDPWR VGND VGND gf180mcu_fd_sc_mcu7t5v0__inv_1
Xk7_ff k_n[7] run k[6] k[7] VDPWR VDPWR VGND VGND gf180mcu_fd_sc_mcu7t5v0__dffnrnq_1
Xk7_inv k[7] k_n[7] VDPWR VDPWR VGND VGND gf180mcu_fd_sc_mcu7t5v0__inv_1
Xk8_ff k_n[8] run k[7] k[8] VDPWR VDPWR VGND VGND gf180mcu_fd_sc_mcu7t5v0__dffnrnq_1
Xk8_inv k[8] k_n[8] VDPWR VDPWR VGND VGND gf180mcu_fd_sc_mcu7t5v0__inv_1
Xk9_ff k_n[9] run k[8] k[9] VDPWR VDPWR VGND VGND gf180mcu_fd_sc_mcu7t5v0__dffnrnq_1
Xk9_inv k[9] k_n[9] VDPWR VDPWR VGND VGND gf180mcu_fd_sc_mcu7t5v0__inv_1
Xn0_ff n_n[0] run tick_n n[0] VDPWR VDPWR VGND VGND gf180mcu_fd_sc_mcu7t5v0__dffnrnq_1
Xn0_inv n[0] n_n[0] VDPWR VDPWR VGND VGND gf180mcu_fd_sc_mcu7t5v0__inv_1
Xn10_ff n_n[10] run n[9] n[10] VDPWR VDPWR VGND VGND gf180mcu_fd_sc_mcu7t5v0__dffnrnq_1
Xn10_inv n[10] n_n[10] VDPWR VDPWR VGND VGND gf180mcu_fd_sc_mcu7t5v0__inv_1
Xn11_ff n_n[11] run n[10] n[11] VDPWR VDPWR VGND VGND gf180mcu_fd_sc_mcu7t5v0__dffnrnq_1
Xn11_inv n[11] n_n[11] VDPWR VDPWR VGND VGND gf180mcu_fd_sc_mcu7t5v0__inv_1
Xn12_ff n_n[12] run n[11] n[12] VDPWR VDPWR VGND VGND gf180mcu_fd_sc_mcu7t5v0__dffnrnq_1
Xn12_inv n[12] n_n[12] VDPWR VDPWR VGND VGND gf180mcu_fd_sc_mcu7t5v0__inv_1
Xn13_ff n_n[13] run n[12] n[13] VDPWR VDPWR VGND VGND gf180mcu_fd_sc_mcu7t5v0__dffnrnq_1
Xn13_inv n[13] n_n[13] VDPWR VDPWR VGND VGND gf180mcu_fd_sc_mcu7t5v0__inv_1
Xn14_ff n_n[14] run n[13] n[14] VDPWR VDPWR VGND VGND gf180mcu_fd_sc_mcu7t5v0__dffnrnq_1
Xn14_inv n[14] n_n[14] VDPWR VDPWR VGND VGND gf180mcu_fd_sc_mcu7t5v0__inv_1
Xn15_ff n_n[15] run n[14] n[15] VDPWR VDPWR VGND VGND gf180mcu_fd_sc_mcu7t5v0__dffnrnq_1
Xn15_inv n[15] n_n[15] VDPWR VDPWR VGND VGND gf180mcu_fd_sc_mcu7t5v0__inv_1
Xn16_ff n_n[16] run n[15] n[16] VDPWR VDPWR VGND VGND gf180mcu_fd_sc_mcu7t5v0__dffnrnq_1
Xn16_inv n[16] n_n[16] VDPWR VDPWR VGND VGND gf180mcu_fd_sc_mcu7t5v0__inv_1
Xn1_ff n_n[1] run n_n[0] n[1] VDPWR VDPWR VGND VGND gf180mcu_fd_sc_mcu7t5v0__dffnrnq_1
Xn1_inv n[1] n_n[1] VDPWR VDPWR VGND VGND gf180mcu_fd_sc_mcu7t5v0__inv_1
Xn2_ff n_n[2] run n[1] n[2] VDPWR VDPWR VGND VGND gf180mcu_fd_sc_mcu7t5v0__dffnrnq_1
Xn2_inv n[2] n_n[2] VDPWR VDPWR VGND VGND gf180mcu_fd_sc_mcu7t5v0__inv_1
Xn3_ff n_n[3] run n[2] n[3] VDPWR VDPWR VGND VGND gf180mcu_fd_sc_mcu7t5v0__dffnrnq_1
Xn3_inv n[3] n_n[3] VDPWR VDPWR VGND VGND gf180mcu_fd_sc_mcu7t5v0__inv_1
Xn4_ff n_n[4] run n[3] n[4] VDPWR VDPWR VGND VGND gf180mcu_fd_sc_mcu7t5v0__dffnrnq_1
Xn4_inv n[4] n_n[4] VDPWR VDPWR VGND VGND gf180mcu_fd_sc_mcu7t5v0__inv_1
Xn5_ff n_n[5] run n[4] n[5] VDPWR VDPWR VGND VGND gf180mcu_fd_sc_mcu7t5v0__dffnrnq_1
Xn5_inv n[5] n_n[5] VDPWR VDPWR VGND VGND gf180mcu_fd_sc_mcu7t5v0__inv_1
Xn6_ff n_n[6] run n[5] n[6] VDPWR VDPWR VGND VGND gf180mcu_fd_sc_mcu7t5v0__dffnrnq_1
Xn6_inv n[6] n_n[6] VDPWR VDPWR VGND VGND gf180mcu_fd_sc_mcu7t5v0__inv_1
Xn7_ff n_n[7] run n[6] n[7] VDPWR VDPWR VGND VGND gf180mcu_fd_sc_mcu7t5v0__dffnrnq_1
Xn7_inv n[7] n_n[7] VDPWR VDPWR VGND VGND gf180mcu_fd_sc_mcu7t5v0__inv_1
Xn8_ff n_n[8] run n[7] n[8] VDPWR VDPWR VGND VGND gf180mcu_fd_sc_mcu7t5v0__dffnrnq_1
Xn8_inv n[8] n_n[8] VDPWR VDPWR VGND VGND gf180mcu_fd_sc_mcu7t5v0__inv_1
Xn9_ff n_n[9] run n[8] n[9] VDPWR VDPWR VGND VGND gf180mcu_fd_sc_mcu7t5v0__dffnrnq_1
Xn9_inv n[9] n_n[9] VDPWR VDPWR VGND VGND gf180mcu_fd_sc_mcu7t5v0__inv_1
Xk0_ff k0_d run tick_n k[0] VDPWR VDPWR VGND VGND gf180mcu_fd_sc_mcu7t5v0__dffnrnq_1
Xk0_xor k[0] event_bit k0_d VDPWR VDPWR VGND VGND gf180mcu_fd_sc_mcu7t5v0__xor2_1
Xl1_ff q_selected b l1 VDPWR VDPWR VGND VGND gf180mcu_fd_sc_mcu7t5v0__dffnq_1
Xl2_ff q_selected a_n l2 VDPWR VDPWR VGND VGND gf180mcu_fd_sc_mcu7t5v0__dffq_1
Xrequest_and ena start request VDPWR VDPWR VGND VGND gf180mcu_fd_sc_mcu7t5v0__and2_1
Xrun_ff start_meta rst_n a_n run VDPWR VDPWR VGND VGND gf180mcu_fd_sc_mcu7t5v0__dffrnq_1
Xstart_meta_ff request rst_n a_n start_meta VDPWR VDPWR VGND VGND gf180mcu_fd_sc_mcu7t5v0__dffrnq_1
Xtick_nand b allow_count tick_n VDPWR VDPWR VGND VGND gf180mcu_fd_sc_mcu7t5v0__nand2_1
Xwant_and run finished_n want_count VDPWR VDPWR VGND VGND gf180mcu_fd_sc_mcu7t5v0__and2_1
.ENDS

.SUBCKT tt_um_metastability_characterizer VDPWR VGND ui_in[0] ui_in[1] ui_in[2] ui_in[3] ui_in[4] ui_in[5] ui_in[6] ui_in[7] uo_out[0] uo_out[1] uo_out[2] uo_out[3] uo_out[4] uo_out[5] uo_out[6] uo_out[7] uio_in[0] uio_in[1] uio_in[2] uio_in[3] uio_in[4] uio_in[5] uio_in[6] uio_in[7] uio_out[0] uio_out[1] uio_out[2] uio_out[3] uio_out[4] uio_out[5] uio_out[6] uio_out[7] uio_oe[0] uio_oe[1] uio_oe[2] uio_oe[3] uio_oe[4] uio_oe[5] uio_oe[6] uio_oe[7] ua[0] ua[1] ua[2] ua[3] ua[4] ua[5] ua[6] ua[7] ena clk rst_n
Xcontroller clk rst_n ena ui_in[4] ctrl_q ctrl_early ui_in[0] capture uio_out[1] uio_out[2] uio_out[3] uo_out[0] uo_out[1] uo_out[2] uo_out[3] uo_out[4] uo_out[5] uo_out[6] uo_out[7] VDPWR VGND compact_control
Xdata0 ui_in[6] data_b VDPWR VDPWR VGND VGND gf180mcu_fd_sc_mcu7t5v0__inv_2
Xdata1 data_b data_local VDPWR VDPWR VGND VGND gf180mcu_fd_sc_mcu7t5v0__inv_2
Xcap0 capture capture_b VDPWR VDPWR VGND VGND gf180mcu_fd_sc_mcu7t5v0__inv_2
Xcap1 capture_b capture_local VDPWR VDPWR VGND VGND gf180mcu_fd_sc_mcu7t5v0__inv_2
Xu_dut1 data_local capture_local q[0] VDPWR VDPWR VGND VGND gf180mcu_fd_sc_mcu7t5v0__dffq_1
Xselect_dut q[0] q[1] q[2] q[3] ui_in[3] uio_in[6] selected_q VDPWR VDPWR VGND VGND gf180mcu_fd_sc_mcu7t5v0__mux4_1
Xiso0 capture_local capture_iso_b VDPWR VDPWR VGND VGND gf180mcu_fd_sc_mcu7t5v0__inv_1
Xiso1 capture_iso_b capture_iso VDPWR VDPWR VGND VGND gf180mcu_fd_sc_mcu7t5v0__inv_2
Xant_ctrl ua[0] VDPWR VDPWR VGND VGND gf180mcu_fd_sc_mcu7t5v0__antenna
Xearly_observer selected_q early_clk early_q VDPWR VDPWR VGND VGND gf180mcu_fd_sc_mcu7t5v0__dffq_1
Xmonitor_capture_a capture_local capmon_n VDPWR VDPWR VGND VGND gf180mcu_fd_sc_mcu7t5v0__inv_1
Xmonitor_capture_b capmon_n uio_out[4] VDPWR VDPWR VGND VGND gf180mcu_fd_sc_mcu7t5v0__inv_2
Xmonitor_early_a early_clk earlymon_n VDPWR VDPWR VGND VGND gf180mcu_fd_sc_mcu7t5v0__inv_1
Xmonitor_early_b earlymon_n uio_out[5] VDPWR VDPWR VGND VGND gf180mcu_fd_sc_mcu7t5v0__inv_2
Xoe_buf1 ena uio_oe[1] VDPWR VDPWR VGND VGND gf180mcu_fd_sc_mcu7t5v0__buf_1
Xoe_buf2 ena uio_oe[2] VDPWR VDPWR VGND VGND gf180mcu_fd_sc_mcu7t5v0__buf_1
Xoe_buf3 ena uio_oe[3] VDPWR VDPWR VGND VGND gf180mcu_fd_sc_mcu7t5v0__buf_1
Xoe_buf4 ena uio_oe[4] VDPWR VDPWR VGND VGND gf180mcu_fd_sc_mcu7t5v0__buf_1
Xoe_buf5 ena uio_oe[5] VDPWR VDPWR VGND VGND gf180mcu_fd_sc_mcu7t5v0__buf_1
Xtielo_uio_oe0 uio_oe[0] VDPWR VDPWR VGND VGND gf180mcu_fd_sc_mcu7t5v0__tiel
Xtielo_uio_oe6 uio_oe[6] VDPWR VDPWR VGND VGND gf180mcu_fd_sc_mcu7t5v0__tiel
Xtielo_uio_oe7 uio_oe[7] VDPWR VDPWR VGND VGND gf180mcu_fd_sc_mcu7t5v0__tiel
Xtielo_uio_out0 uio_out[0] VDPWR VDPWR VGND VGND gf180mcu_fd_sc_mcu7t5v0__tiel
Xtielo_uio_out6 uio_out[6] VDPWR VDPWR VGND VGND gf180mcu_fd_sc_mcu7t5v0__tiel
Xtielo_uio_out7 uio_out[7] VDPWR VDPWR VGND VGND gf180mcu_fd_sc_mcu7t5v0__tiel
Xu_dut2 data_local capture_local q[1] VDPWR VGND meta_dut_baseline
Xu_dut3 data_local capture_local q[2] VDPWR VGND meta_dut_keeper
Xu_dut4 data_local capture_local q[3] VDPWR VGND meta_dut_forward
Xdelay capture_iso ua[0] early_clk VDPWR VGND meta_delay_analog
* Constant outputs: tie-low cells (tielo_*) and ena buffers (oe_buf*), one driver per pin
* Flip-flop bank: trial clock copy, capture and data drivers, selector, early observer, joins
Xbank_a_ff bank_b clk bank_a VDPWR VDPWR VGND VGND gf180mcu_fd_sc_mcu7t5v0__dffq_1
Xbank_a_inv bank_a bank_a_n VDPWR VDPWR VGND VGND gf180mcu_fd_sc_mcu7t5v0__inv_1
Xbank_b_ff bank_a_n rst_n clk bank_b VDPWR VDPWR VGND VGND gf180mcu_fd_sc_mcu7t5v0__dffrnq_1
Xbank_cap0 bank_a bank_cap_b VDPWR VDPWR VGND VGND gf180mcu_fd_sc_mcu7t5v0__inv_4
Xbank_cap1 bank_cap_b bank_cap VDPWR VDPWR VGND VGND gf180mcu_fd_sc_mcu7t5v0__inv_12
Xbank_data0 uio_in[0] bank_data_b VDPWR VDPWR VGND VGND gf180mcu_fd_sc_mcu7t5v0__inv_2
Xbank_data1 bank_data_b bank_data VDPWR VDPWR VGND VGND gf180mcu_fd_sc_mcu7t5v0__inv_2
Xbank_select bank_q[0] bank_q[1] bank_q[2] bank_zero ui_in[1] ui_in[2] bank_selected_q VDPWR VDPWR VGND VGND gf180mcu_fd_sc_mcu7t5v0__mux4_1
Xbank_tie bank_zero VDPWR VDPWR VGND VGND gf180mcu_fd_sc_mcu7t5v0__tiel
Xbank_obs0 ui_in[5] bank_obs_b VDPWR VDPWR VGND VGND gf180mcu_fd_sc_mcu7t5v0__inv_1
Xbank_obs1 bank_obs_b bank_obs_clk VDPWR VDPWR VGND VGND gf180mcu_fd_sc_mcu7t5v0__inv_2
Xbank_observer bank_selected_q bank_obs_clk bank_early_q VDPWR VDPWR VGND VGND gf180mcu_fd_sc_mcu7t5v0__dffq_1
Xjoin_q selected_q bank_selected_q ui_in[7] ctrl_q VDPWR VDPWR VGND VGND gf180mcu_fd_sc_mcu7t5v0__mux2_1
Xjoin_e early_q bank_early_q ui_in[7] ctrl_early VDPWR VDPWR VGND VGND gf180mcu_fd_sc_mcu7t5v0__mux2_1
Xbank_n1 bank_data bank_cap bank_q[0] VDPWR VGND meta_dut_n3ffb
Xbank_n2 bank_data bank_cap bank_q[1] VDPWR VGND meta_dut_j3a
Xbank_n3 bank_data bank_cap bank_q[2] VDPWR VGND meta_dut_keeper
.ENDS
