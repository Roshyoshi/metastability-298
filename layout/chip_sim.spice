* Pre-layout simulation netlist of tt_um_metastability_characterizer (generated; PDK cell subcircuits with junction geometry)
.SUBCKT gf180mcu_fd_sc_mcu7t5v0__and2_1 A1 A2 Z VDD VNW VPW VSS
X_i_2 net_0 A1 Z_neg VPW nfet_05v0 W=3.65e-07 L=6e-07 ad=1.825e-13 as=1.825e-13 pd=1.73e-06 ps=1.73e-06
X_i_3 VSS A2 net_0 VPW nfet_05v0 W=3.65e-07 L=6e-07 ad=1.825e-13 as=1.825e-13 pd=1.73e-06 ps=1.73e-06
X_i_0 Z Z_neg VSS VPW nfet_05v0 W=8.15e-07 L=6e-07 ad=4.075e-13 as=4.075e-13 pd=2.63e-06 ps=2.63e-06
X_i_4 Z_neg A1 VDD VNW pfet_05v0 W=6e-07 L=5e-07 ad=3e-13 as=3e-13 pd=2.2e-06 ps=2.2e-06
X_i_5 VDD A2 Z_neg VNW pfet_05v0 W=6e-07 L=5e-07 ad=3e-13 as=3e-13 pd=2.2e-06 ps=2.2e-06
X_i_1 Z Z_neg VDD VNW pfet_05v0 W=1.215e-06 L=5e-07 ad=6.075e-13 as=6.075e-13 pd=3.43e-06 ps=3.43e-06
.ENDS
.SUBCKT gf180mcu_fd_sc_mcu7t5v0__antenna I VDD VNW VPW VSS
D0 VPW I diode_nd2ps_06v0 AREA=0.2052p PJ=1.86u M=1
D1 I VNW diode_pd2nw_06v0 AREA=0.2052p PJ=1.86u M=1
.ENDS
.SUBCKT gf180mcu_fd_sc_mcu7t5v0__buf_1 I Z VDD VNW VPW VSS
X_i_2 VSS I Z_neg VPW nfet_05v0 W=3.6e-07 L=6e-07 ad=1.8e-13 as=1.8e-13 pd=1.72e-06 ps=1.72e-06
X_i_0 Z Z_neg VSS VPW nfet_05v0 W=8.2e-07 L=6e-07 ad=4.1e-13 as=4.1e-13 pd=2.64e-06 ps=2.64e-06
X_i_3 VDD I Z_neg VNW pfet_05v0 W=5.65e-07 L=5e-07 ad=2.825e-13 as=2.825e-13 pd=2.13e-06 ps=2.13e-06
X_i_1 Z Z_neg VDD VNW pfet_05v0 W=1.22e-06 L=5e-07 ad=6.1e-13 as=6.1e-13 pd=3.44e-06 ps=3.44e-06
.ENDS
.SUBCKT gf180mcu_fd_sc_mcu7t5v0__dffnq_1 D CLKN Q VDD VNW VPW VSS
X_tn9 ncki CLKN VSS VPW nfet_05v0 W=4.65e-07 L=6e-07 ad=2.325e-13 as=2.325e-13 pd=1.93e-06 ps=1.93e-06
X_tn16 cki ncki VSS VPW nfet_05v0 W=4.65e-07 L=6e-07 ad=2.325e-13 as=2.325e-13 pd=1.93e-06 ps=1.93e-06
X_tn10 VSS D net2 VPW nfet_05v0 W=3.6e-07 L=6e-07 ad=1.8e-13 as=1.8e-13 pd=1.72e-06 ps=1.72e-06
X_tn11 net2 cki net5 VPW nfet_05v0 W=3.6e-07 L=6e-07 ad=1.8e-13 as=1.8e-13 pd=1.72e-06 ps=1.72e-06
X_tn0 net5 ncki net11 VPW nfet_05v0 W=3.6e-07 L=6e-07 ad=1.8e-13 as=1.8e-13 pd=1.72e-06 ps=1.72e-06
X_tn1 VSS net10 net11 VPW nfet_05v0 W=3.6e-07 L=6e-07 ad=1.8e-13 as=1.8e-13 pd=1.72e-06 ps=1.72e-06
X_tn15 net10 net5 VSS VPW nfet_05v0 W=3.6e-07 L=6e-07 ad=1.8e-13 as=1.8e-13 pd=1.72e-06 ps=1.72e-06
X_tn2 net0 ncki net10 VPW nfet_05v0 W=3.6e-07 L=6e-07 ad=1.8e-13 as=1.8e-13 pd=1.72e-06 ps=1.72e-06
X_tn3 net7 cki net0 VPW nfet_05v0 W=3.6e-07 L=6e-07 ad=1.8e-13 as=1.8e-13 pd=1.72e-06 ps=1.72e-06
X_tn4 VSS net1 net7 VPW nfet_05v0 W=6.3e-07 L=6e-07 ad=3.15e-13 as=3.15e-13 pd=2.26e-06 ps=2.26e-06
X_tn5 net1 net0 VSS VPW nfet_05v0 W=6.3e-07 L=6e-07 ad=3.15e-13 as=3.15e-13 pd=2.26e-06 ps=2.26e-06
X_tn6 Q net1 VSS VPW nfet_05v0 W=8.2e-07 L=6e-07 ad=4.1e-13 as=4.1e-13 pd=2.64e-06 ps=2.64e-06
X_tp9 ncki CLKN VDD VNW pfet_05v0 W=8.65e-07 L=5e-07 ad=4.325e-13 as=4.325e-13 pd=2.73e-06 ps=2.73e-06
X_tp16 cki ncki VDD VNW pfet_05v0 W=8.65e-07 L=5e-07 ad=4.325e-13 as=4.325e-13 pd=2.73e-06 ps=2.73e-06
X_tp10 VDD D net2 VNW pfet_05v0 W=4.95e-07 L=5e-07 ad=2.475e-13 as=2.475e-13 pd=1.99e-06 ps=1.99e-06
X_tp11 net5 ncki net2 VNW pfet_05v0 W=4.95e-07 L=5e-07 ad=2.475e-13 as=2.475e-13 pd=1.99e-06 ps=1.99e-06
X_tp0 net4 cki net5 VNW pfet_05v0 W=4.95e-07 L=5e-07 ad=2.475e-13 as=2.475e-13 pd=1.99e-06 ps=1.99e-06
X_tp1 VDD net10 net4 VNW pfet_05v0 W=4.95e-07 L=5e-07 ad=2.475e-13 as=2.475e-13 pd=1.99e-06 ps=1.99e-06
X_tp15 net10 net5 VDD VNW pfet_05v0 W=4.95e-07 L=5e-07 ad=2.475e-13 as=2.475e-13 pd=1.99e-06 ps=1.99e-06
X_tp7 net0 cki net10 VNW pfet_05v0 W=4.95e-07 L=5e-07 ad=2.475e-13 as=2.475e-13 pd=1.99e-06 ps=1.99e-06
X_tp6 net7 ncki net0 VNW pfet_05v0 W=4.95e-07 L=5e-07 ad=2.475e-13 as=2.475e-13 pd=1.99e-06 ps=1.99e-06
X_tp2 VDD net1 net7 VNW pfet_05v0 W=1.075e-06 L=5e-07 ad=5.375e-13 as=5.375e-13 pd=3.15e-06 ps=3.15e-06
X_tp3 net1 net0 VDD VNW pfet_05v0 W=1.075e-06 L=5e-07 ad=5.375e-13 as=5.375e-13 pd=3.15e-06 ps=3.15e-06
X_tp4 Q net1 VDD VNW pfet_05v0 W=1.13e-06 L=5e-07 ad=5.65e-13 as=5.65e-13 pd=3.26e-06 ps=3.26e-06
.ENDS
.SUBCKT gf180mcu_fd_sc_mcu7t5v0__dffnrnq_1 D RN CLKN Q VDD VNW VPW VSS
X_tn13 ncki CLKN VSS VPW nfet_05v0 W=4.05e-07 L=6e-07 ad=2.025e-13 as=2.025e-13 pd=1.81e-06 ps=1.81e-06
X_tn10 cki ncki VSS VPW nfet_05v0 W=4.05e-07 L=6e-07 ad=2.025e-13 as=2.025e-13 pd=1.81e-06 ps=1.81e-06
X_tn11 net6 D VSS VPW nfet_05v0 W=3.9e-07 L=6e-07 ad=1.95e-13 as=1.95e-13 pd=1.78e-06 ps=1.78e-06
X_tn15 net6 cki net1 VPW nfet_05v0 W=3.9e-07 L=6e-07 ad=1.95e-13 as=1.95e-13 pd=1.78e-06 ps=1.78e-06
X_tn14 net1 ncki net15 VPW nfet_05v0 W=3.9e-07 L=6e-07 ad=1.95e-13 as=1.95e-13 pd=1.78e-06 ps=1.78e-06
X_tn8 net12 net2 net15 VPW nfet_05v0 W=3.9e-07 L=6e-07 ad=1.95e-13 as=1.95e-13 pd=1.78e-06 ps=1.78e-06
X_tn9 VSS RN net12 VPW nfet_05v0 W=3.9e-07 L=6e-07 ad=1.95e-13 as=1.95e-13 pd=1.78e-06 ps=1.78e-06
X_tn18 VSS net1 net2 VPW nfet_05v0 W=3.9e-07 L=6e-07 ad=1.95e-13 as=1.95e-13 pd=1.78e-06 ps=1.78e-06
X_tn0 net8 ncki net2 VPW nfet_05v0 W=3.9e-07 L=6e-07 ad=1.95e-13 as=1.95e-13 pd=1.78e-06 ps=1.78e-06
X_tn1 net11 cki net8 VPW nfet_05v0 W=3.9e-07 L=6e-07 ad=1.95e-13 as=1.95e-13 pd=1.78e-06 ps=1.78e-06
X_tn12 net11 net4 VSS VPW nfet_05v0 W=3.9e-07 L=6e-07 ad=1.95e-13 as=1.95e-13 pd=1.78e-06 ps=1.78e-06
X_tn5 net0 RN VSS VPW nfet_05v0 W=3.9e-07 L=6e-07 ad=1.95e-13 as=1.95e-13 pd=1.78e-06 ps=1.78e-06
X_tn4 net4 net8 net0 VPW nfet_05v0 W=4e-07 L=6e-07 ad=2e-13 as=2e-13 pd=1.8e-06 ps=1.8e-06
X_tn3 Q net4 VSS VPW nfet_05v0 W=7.95e-07 L=6e-07 ad=3.975e-13 as=3.975e-13 pd=2.59e-06 ps=2.59e-06
X_tp11 ncki CLKN VDD VNW pfet_05v0 W=8.65e-07 L=5e-07 ad=4.325e-13 as=4.325e-13 pd=2.73e-06 ps=2.73e-06
X_tp8 cki ncki VDD VNW pfet_05v0 W=8.65e-07 L=5e-07 ad=4.325e-13 as=4.325e-13 pd=2.73e-06 ps=2.73e-06
X_tp9 VDD D net6 VNW pfet_05v0 W=7.6e-07 L=5e-07 ad=3.8e-13 as=3.8e-13 pd=2.52e-06 ps=2.52e-06
X_tp15 net1 ncki net6 VNW pfet_05v0 W=7.6e-07 L=5e-07 ad=3.8e-13 as=3.8e-13 pd=2.52e-06 ps=2.52e-06
X_tp7 net9 cki net1 VNW pfet_05v0 W=7.6e-07 L=5e-07 ad=3.8e-13 as=3.8e-13 pd=2.52e-06 ps=2.52e-06
X_tp6 VDD net2 net9 VNW pfet_05v0 W=7.6e-07 L=5e-07 ad=3.8e-13 as=3.8e-13 pd=2.52e-06 ps=2.52e-06
X_tp12 net9 RN VDD VNW pfet_05v0 W=7.6e-07 L=5e-07 ad=3.8e-13 as=3.8e-13 pd=2.52e-06 ps=2.52e-06
X_tp18 VDD net1 net2 VNW pfet_05v0 W=5.05e-07 L=5e-07 ad=2.525e-13 as=2.525e-13 pd=2.01e-06 ps=2.01e-06
X_tp2 net2 cki net8 VNW pfet_05v0 W=5.05e-07 L=5e-07 ad=2.525e-13 as=2.525e-13 pd=2.01e-06 ps=2.01e-06
X_tp3 net8 ncki net11 VNW pfet_05v0 W=5.05e-07 L=5e-07 ad=2.525e-13 as=2.525e-13 pd=2.01e-06 ps=2.01e-06
X_tp10 net11 net4 VDD VNW pfet_05v0 W=5.05e-07 L=5e-07 ad=2.525e-13 as=2.525e-13 pd=2.01e-06 ps=2.01e-06
X_tp5 net4 RN VDD VNW pfet_05v0 W=9.4e-07 L=5e-07 ad=4.7e-13 as=4.7e-13 pd=2.88e-06 ps=2.88e-06
X_tp4 VDD net8 net4 VNW pfet_05v0 W=9.4e-07 L=5e-07 ad=4.7e-13 as=4.7e-13 pd=2.88e-06 ps=2.88e-06
X_tp1 Q net4 VDD VNW pfet_05v0 W=1.175e-06 L=5e-07 ad=5.875e-13 as=5.875e-13 pd=3.35e-06 ps=3.35e-06
.ENDS
.SUBCKT gf180mcu_fd_sc_mcu7t5v0__dffq_1 D CLK Q VDD VNW VPW VSS
X_tn3 VSS CLK ncki VPW nfet_05v0 W=4.05e-07 L=6e-07 ad=2.025e-13 as=2.025e-13 pd=1.81e-06 ps=1.81e-06
X_tn4 cki ncki VSS VPW nfet_05v0 W=4.05e-07 L=6e-07 ad=2.025e-13 as=2.025e-13 pd=1.81e-06 ps=1.81e-06
X_tn5 net5 ncki VSS VPW nfet_05v0 W=3.6e-07 L=6e-07 ad=1.8e-13 as=1.8e-13 pd=1.72e-06 ps=1.72e-06
X_tn8 net4 D net5 VPW nfet_05v0 W=3.6e-07 L=6e-07 ad=1.8e-13 as=1.8e-13 pd=1.72e-06 ps=1.72e-06
X_tn6 net6 cki net4 VPW nfet_05v0 W=3.6e-07 L=6e-07 ad=1.8e-13 as=1.8e-13 pd=1.72e-06 ps=1.72e-06
X_tn7 VSS net0 net6 VPW nfet_05v0 W=3.6e-07 L=6e-07 ad=1.8e-13 as=1.8e-13 pd=1.72e-06 ps=1.72e-06
X_tn0 net0 net4 VSS VPW nfet_05v0 W=3.6e-07 L=6e-07 ad=1.8e-13 as=1.8e-13 pd=1.72e-06 ps=1.72e-06
X_tn9 net2 cki net0 VPW nfet_05v0 W=3.6e-07 L=6e-07 ad=1.8e-13 as=1.8e-13 pd=1.72e-06 ps=1.72e-06
X_tn11 net1 ncki net2 VPW nfet_05v0 W=3.6e-07 L=6e-07 ad=1.8e-13 as=1.8e-13 pd=1.72e-06 ps=1.72e-06
X_tn12 VSS net3 net1 VPW nfet_05v0 W=3.6e-07 L=6e-07 ad=1.8e-13 as=1.8e-13 pd=1.72e-06 ps=1.72e-06
X_tn10 net3 net2 VSS VPW nfet_05v0 W=4e-07 L=6e-07 ad=2e-13 as=2e-13 pd=1.8e-06 ps=1.8e-06
X_tn1 Q net3 VSS VPW nfet_05v0 W=8.2e-07 L=6e-07 ad=4.1e-13 as=4.1e-13 pd=2.64e-06 ps=2.64e-06
X_tp3 VDD CLK ncki VNW pfet_05v0 W=8.65e-07 L=5e-07 ad=4.325e-13 as=4.325e-13 pd=2.73e-06 ps=2.73e-06
X_tp4 cki ncki VDD VNW pfet_05v0 W=8.65e-07 L=5e-07 ad=4.325e-13 as=4.325e-13 pd=2.73e-06 ps=2.73e-06
X_tp12 net7 cki VDD VNW pfet_05v0 W=3.6e-07 L=5e-07 ad=1.8e-13 as=1.8e-13 pd=1.72e-06 ps=1.72e-06
X_tp11 net4 D net7 VNW pfet_05v0 W=3.6e-07 L=5e-07 ad=1.8e-13 as=1.8e-13 pd=1.72e-06 ps=1.72e-06
X_tp6 net8 ncki net4 VNW pfet_05v0 W=3.6e-07 L=5e-07 ad=1.8e-13 as=1.8e-13 pd=1.72e-06 ps=1.72e-06
X_tp5 VDD net0 net8 VNW pfet_05v0 W=3.6e-07 L=5e-07 ad=1.8e-13 as=1.8e-13 pd=1.72e-06 ps=1.72e-06
X_tp0 net0 net4 VDD VNW pfet_05v0 W=3.6e-07 L=5e-07 ad=1.8e-13 as=1.8e-13 pd=1.72e-06 ps=1.72e-06
X_tp7 net2 ncki net0 VNW pfet_05v0 W=3.6e-07 L=5e-07 ad=1.8e-13 as=1.8e-13 pd=1.72e-06 ps=1.72e-06
X_tp9 net1x cki net2 VNW pfet_05v0 W=3.6e-07 L=5e-07 ad=1.8e-13 as=1.8e-13 pd=1.72e-06 ps=1.72e-06
X_tp10 VDD net3 net1x VNW pfet_05v0 W=3.6e-07 L=5e-07 ad=1.8e-13 as=1.8e-13 pd=1.72e-06 ps=1.72e-06
X_tp8 net3 net2 VDD VNW pfet_05v0 W=8e-07 L=5e-07 ad=4e-13 as=4e-13 pd=2.6e-06 ps=2.6e-06
X_tp1 Q net3 VDD VNW pfet_05v0 W=1.22e-06 L=5e-07 ad=6.1e-13 as=6.1e-13 pd=3.44e-06 ps=3.44e-06
.ENDS
.SUBCKT gf180mcu_fd_sc_mcu7t5v0__dffrnq_1 D RN CLK Q VDD VNW VPW VSS
X_tn10 ncki CLK VSS VPW nfet_05v0 W=4.05e-07 L=6e-07 ad=2.025e-13 as=2.025e-13 pd=1.81e-06 ps=1.81e-06
X_tn13 cki ncki VSS VPW nfet_05v0 W=4.05e-07 L=6e-07 ad=2.025e-13 as=2.025e-13 pd=1.81e-06 ps=1.81e-06
X_tn11 net10 D VSS VPW nfet_05v0 W=3.6e-07 L=6e-07 ad=1.8e-13 as=1.8e-13 pd=1.72e-06 ps=1.72e-06
X_tn15 net10 ncki net1 VPW nfet_05v0 W=3.6e-07 L=6e-07 ad=1.8e-13 as=1.8e-13 pd=1.72e-06 ps=1.72e-06
X_tn14 net1 cki net15 VPW nfet_05v0 W=3.6e-07 L=6e-07 ad=1.8e-13 as=1.8e-13 pd=1.72e-06 ps=1.72e-06
X_tn8 net12 net2 net15 VPW nfet_05v0 W=3.6e-07 L=6e-07 ad=1.8e-13 as=1.8e-13 pd=1.72e-06 ps=1.72e-06
X_tn9 VSS RN net12 VPW nfet_05v0 W=3.6e-07 L=6e-07 ad=1.8e-13 as=1.8e-13 pd=1.72e-06 ps=1.72e-06
X_tn18 VSS net1 net2 VPW nfet_05v0 W=3.6e-07 L=6e-07 ad=1.8e-13 as=1.8e-13 pd=1.72e-06 ps=1.72e-06
X_tn0 net8 cki net2 VPW nfet_05v0 W=3.6e-07 L=6e-07 ad=1.8e-13 as=1.8e-13 pd=1.72e-06 ps=1.72e-06
X_tn1 net11 ncki net8 VPW nfet_05v0 W=3.6e-07 L=6e-07 ad=1.8e-13 as=1.8e-13 pd=1.72e-06 ps=1.72e-06
X_tn12 net11 net4 VSS VPW nfet_05v0 W=3.6e-07 L=6e-07 ad=1.8e-13 as=1.8e-13 pd=1.72e-06 ps=1.72e-06
X_tn5 net0 RN VSS VPW nfet_05v0 W=3.6e-07 L=6e-07 ad=1.8e-13 as=1.8e-13 pd=1.72e-06 ps=1.72e-06
X_tn4 net4 net8 net0 VPW nfet_05v0 W=4e-07 L=6e-07 ad=2e-13 as=2e-13 pd=1.8e-06 ps=1.8e-06
X_tn3 Q net4 VSS VPW nfet_05v0 W=8.15e-07 L=6e-07 ad=4.075e-13 as=4.075e-13 pd=2.63e-06 ps=2.63e-06
X_tp8 ncki CLK VDD VNW pfet_05v0 W=8.65e-07 L=5e-07 ad=4.325e-13 as=4.325e-13 pd=2.73e-06 ps=2.73e-06
X_tp11 cki ncki VDD VNW pfet_05v0 W=8.65e-07 L=5e-07 ad=4.325e-13 as=4.325e-13 pd=2.73e-06 ps=2.73e-06
X_tp9 VDD D net10 VNW pfet_05v0 W=7.8e-07 L=5e-07 ad=3.9e-13 as=3.9e-13 pd=2.56e-06 ps=2.56e-06
X_tp15 net1 cki net10 VNW pfet_05v0 W=7.8e-07 L=5e-07 ad=3.9e-13 as=3.9e-13 pd=2.56e-06 ps=2.56e-06
X_tp7 net9 ncki net1 VNW pfet_05v0 W=7.8e-07 L=5e-07 ad=3.9e-13 as=3.9e-13 pd=2.56e-06 ps=2.56e-06
X_tp6 VDD net2 net9 VNW pfet_05v0 W=7.8e-07 L=5e-07 ad=3.9e-13 as=3.9e-13 pd=2.56e-06 ps=2.56e-06
X_tp12 net9 RN VDD VNW pfet_05v0 W=7.8e-07 L=5e-07 ad=3.9e-13 as=3.9e-13 pd=2.56e-06 ps=2.56e-06
X_tp18 VDD net1 net2 VNW pfet_05v0 W=5.05e-07 L=5e-07 ad=2.525e-13 as=2.525e-13 pd=2.01e-06 ps=2.01e-06
X_tp2 net2 ncki net8 VNW pfet_05v0 W=5.05e-07 L=5e-07 ad=2.525e-13 as=2.525e-13 pd=2.01e-06 ps=2.01e-06
X_tp3 net8 cki net11 VNW pfet_05v0 W=5.05e-07 L=5e-07 ad=2.525e-13 as=2.525e-13 pd=2.01e-06 ps=2.01e-06
X_tp10 net11 net4 VDD VNW pfet_05v0 W=5.05e-07 L=5e-07 ad=2.525e-13 as=2.525e-13 pd=2.01e-06 ps=2.01e-06
X_tp5 net4 RN VDD VNW pfet_05v0 W=1e-06 L=5e-07 ad=5e-13 as=5e-13 pd=3e-06 ps=3e-06
X_tp4 VDD net8 net4 VNW pfet_05v0 W=1e-06 L=5e-07 ad=5e-13 as=5e-13 pd=3e-06 ps=3e-06
X_tp1 Q net4 VDD VNW pfet_05v0 W=1.215e-06 L=5e-07 ad=6.075e-13 as=6.075e-13 pd=3.43e-06 ps=3.43e-06
.ENDS
.SUBCKT gf180mcu_fd_sc_mcu7t5v0__inv_1 I ZN VDD VNW VPW VSS
X_i_0 ZN I VSS VPW nfet_05v0 W=8.2e-07 L=6e-07 ad=4.1e-13 as=4.1e-13 pd=2.64e-06 ps=2.64e-06
X_i_1 ZN I VDD VNW pfet_05v0 W=1.22e-06 L=5e-07 ad=6.1e-13 as=6.1e-13 pd=3.44e-06 ps=3.44e-06
.ENDS
.SUBCKT gf180mcu_fd_sc_mcu7t5v0__inv_2 I ZN VDD VNW VPW VSS
X_i_0_0 ZN I VSS VPW nfet_05v0 W=8.2e-07 L=6e-07 ad=4.1e-13 as=4.1e-13 pd=2.64e-06 ps=2.64e-06
X_i_0_1 VSS I ZN VPW nfet_05v0 W=8.2e-07 L=6e-07 ad=4.1e-13 as=4.1e-13 pd=2.64e-06 ps=2.64e-06
X_i_1_0 ZN I VDD VNW pfet_05v0 W=1.22e-06 L=5e-07 ad=6.1e-13 as=6.1e-13 pd=3.44e-06 ps=3.44e-06
X_i_1_1 VDD I ZN VNW pfet_05v0 W=1.22e-06 L=5e-07 ad=6.1e-13 as=6.1e-13 pd=3.44e-06 ps=3.44e-06
.ENDS
.SUBCKT gf180mcu_fd_sc_mcu7t5v0__mux2_1 I0 I1 S Z VDD VNW VPW VSS
X_MN2 VSS int04 Z VPW nfet_05v0 W=8.2e-07 L=6e-07 ad=4.1e-13 as=4.1e-13 pd=2.64e-06 ps=2.64e-06
X_MN4 net_1 I1 VSS VPW nfet_05v0 W=3.6e-07 L=6e-07 ad=1.8e-13 as=1.8e-13 pd=1.72e-06 ps=1.72e-06
X_MN8 int04 S net_1 VPW nfet_05v0 W=3.6e-07 L=6e-07 ad=1.8e-13 as=1.8e-13 pd=1.72e-06 ps=1.72e-06
X_MN7 net_3 sel1_n int04 VPW nfet_05v0 W=3.6e-07 L=6e-07 ad=1.8e-13 as=1.8e-13 pd=1.72e-06 ps=1.72e-06
X_MN3 VSS I0 net_3 VPW nfet_05v0 W=3.6e-07 L=6e-07 ad=1.8e-13 as=1.8e-13 pd=1.72e-06 ps=1.72e-06
X_MN1 sel1_n S VSS VPW nfet_05v0 W=3.6e-07 L=6e-07 ad=1.8e-13 as=1.8e-13 pd=1.72e-06 ps=1.72e-06
X_MP5 VDD int04 Z VNW pfet_05v0 W=1.22e-06 L=5e-07 ad=6.1e-13 as=6.1e-13 pd=3.44e-06 ps=3.44e-06
X_MP4 net_0 I1 VDD VNW pfet_05v0 W=6.15e-07 L=5e-07 ad=3.075e-13 as=3.075e-13 pd=2.23e-06 ps=2.23e-06
X_MP8 int04 sel1_n net_0 VNW pfet_05v0 W=6.15e-07 L=5e-07 ad=3.075e-13 as=3.075e-13 pd=2.23e-06 ps=2.23e-06
X_MP7 net_2 S int04 VNW pfet_05v0 W=6.15e-07 L=5e-07 ad=3.075e-13 as=3.075e-13 pd=2.23e-06 ps=2.23e-06
X_MP3 VDD I0 net_2 VNW pfet_05v0 W=6.15e-07 L=5e-07 ad=3.075e-13 as=3.075e-13 pd=2.23e-06 ps=2.23e-06
X_MP1 sel1_n S VDD VNW pfet_05v0 W=6.15e-07 L=5e-07 ad=3.075e-13 as=3.075e-13 pd=2.23e-06 ps=2.23e-06
.ENDS
.SUBCKT gf180mcu_fd_sc_mcu7t5v0__mux4_1 I0 I1 I2 I3 S0 S1 Z VDD VNW VPW VSS
X_MN5 int01 I2 VSS VPW nfet_05v0 W=3.65e-07 L=6e-07 ad=1.825e-13 as=1.825e-13 pd=1.73e-06 ps=1.73e-06
X_MN9 int02 sel1_n int01 VPW nfet_05v0 W=3.65e-07 L=6e-07 ad=1.825e-13 as=1.825e-13 pd=1.73e-06 ps=1.73e-06
X_MN10 int07 S0 int02 VPW nfet_05v0 W=3.65e-07 L=6e-07 ad=1.825e-13 as=1.825e-13 pd=1.73e-06 ps=1.73e-06
X_MN6 VSS I3 int07 VPW nfet_05v0 W=3.65e-07 L=6e-07 ad=1.825e-13 as=1.825e-13 pd=1.73e-06 ps=1.73e-06
X_instance_22 Z int03 VSS VPW nfet_05v0 W=3.8e-07 L=6e-07 ad=1.9e-13 as=1.9e-13 pd=1.76e-06 ps=1.76e-06
X_MN12 int03 S1 int02 VPW nfet_05v0 W=3.65e-07 L=6e-07 ad=1.825e-13 as=1.825e-13 pd=1.73e-06 ps=1.73e-06
X_MN11 int04 sel2_n int03 VPW nfet_05v0 W=3.65e-07 L=6e-07 ad=1.825e-13 as=1.825e-13 pd=1.73e-06 ps=1.73e-06
X_MN2 VSS S1 sel2_n VPW nfet_05v0 W=3.65e-07 L=6e-07 ad=1.825e-13 as=1.825e-13 pd=1.73e-06 ps=1.73e-06
X_MN4 int06 I1 VSS VPW nfet_05v0 W=3.65e-07 L=6e-07 ad=1.825e-13 as=1.825e-13 pd=1.73e-06 ps=1.73e-06
X_MN8 int04 S0 int06 VPW nfet_05v0 W=3.65e-07 L=6e-07 ad=1.825e-13 as=1.825e-13 pd=1.73e-06 ps=1.73e-06
X_MN7 int05 sel1_n int04 VPW nfet_05v0 W=3.65e-07 L=6e-07 ad=1.825e-13 as=1.825e-13 pd=1.73e-06 ps=1.73e-06
X_MN3 VSS I0 int05 VPW nfet_05v0 W=3.65e-07 L=6e-07 ad=1.825e-13 as=1.825e-13 pd=1.73e-06 ps=1.73e-06
X_MN1 sel1_n S0 VSS VPW nfet_05v0 W=3.65e-07 L=6e-07 ad=1.825e-13 as=1.825e-13 pd=1.73e-06 ps=1.73e-06
X_MP2 int01 I2 VDD VNW pfet_05v0 W=5.65e-07 L=5e-07 ad=2.825e-13 as=2.825e-13 pd=2.13e-06 ps=2.13e-06
X_MP9 int02 S0 int01 VNW pfet_05v0 W=5.65e-07 L=5e-07 ad=2.825e-13 as=2.825e-13 pd=2.13e-06 ps=2.13e-06
X_MP10 int07 sel1_n int02 VNW pfet_05v0 W=5.65e-07 L=5e-07 ad=2.825e-13 as=2.825e-13 pd=2.13e-06 ps=2.13e-06
X_MP6 VDD I3 int07 VNW pfet_05v0 W=5.65e-07 L=5e-07 ad=2.825e-13 as=2.825e-13 pd=2.13e-06 ps=2.13e-06
X_instance_1 Z int03 VDD VNW pfet_05v0 W=7.8e-07 L=5e-07 ad=3.9e-13 as=3.9e-13 pd=2.56e-06 ps=2.56e-06
X_MP12 int03 sel2_n int02 VNW pfet_05v0 W=5.65e-07 L=5e-07 ad=2.825e-13 as=2.825e-13 pd=2.13e-06 ps=2.13e-06
X_MP11 int04 S1 int03 VNW pfet_05v0 W=5.65e-07 L=5e-07 ad=2.825e-13 as=2.825e-13 pd=2.13e-06 ps=2.13e-06
X_MP5 VDD S1 sel2_n VNW pfet_05v0 W=5.65e-07 L=5e-07 ad=2.825e-13 as=2.825e-13 pd=2.13e-06 ps=2.13e-06
X_MP4 int06 I1 VDD VNW pfet_05v0 W=5.65e-07 L=5e-07 ad=2.825e-13 as=2.825e-13 pd=2.13e-06 ps=2.13e-06
X_MP8 int04 sel1_n int06 VNW pfet_05v0 W=5.65e-07 L=5e-07 ad=2.825e-13 as=2.825e-13 pd=2.13e-06 ps=2.13e-06
X_MP7 int05 S0 int04 VNW pfet_05v0 W=5.65e-07 L=5e-07 ad=2.825e-13 as=2.825e-13 pd=2.13e-06 ps=2.13e-06
X_MP3 VDD I0 int05 VNW pfet_05v0 W=5.65e-07 L=5e-07 ad=2.825e-13 as=2.825e-13 pd=2.13e-06 ps=2.13e-06
X_MP1 sel1_n S0 VDD VNW pfet_05v0 W=5.65e-07 L=5e-07 ad=2.825e-13 as=2.825e-13 pd=2.13e-06 ps=2.13e-06
.ENDS
.SUBCKT gf180mcu_fd_sc_mcu7t5v0__nand2_1 A1 A2 ZN VDD VNW VPW VSS
X_i_1 net_0 A2 VSS VPW nfet_05v0 W=8.2e-07 L=6e-07 ad=4.1e-13 as=4.1e-13 pd=2.64e-06 ps=2.64e-06
X_i_0 ZN A1 net_0 VPW nfet_05v0 W=8.2e-07 L=6e-07 ad=4.1e-13 as=4.1e-13 pd=2.64e-06 ps=2.64e-06
X_i_3 ZN A2 VDD VNW pfet_05v0 W=1.13e-06 L=5e-07 ad=5.65e-13 as=5.65e-13 pd=3.26e-06 ps=3.26e-06
X_i_2 VDD A1 ZN VNW pfet_05v0 W=1.13e-06 L=5e-07 ad=5.65e-13 as=5.65e-13 pd=3.26e-06 ps=3.26e-06
.ENDS
.SUBCKT gf180mcu_fd_sc_mcu7t5v0__nand2_2 A1 A2 ZN VDD VNW VPW VSS
X_i_1_1 net_0_0 A2 VSS VPW nfet_05v0 W=8.2e-07 L=6e-07 ad=4.1e-13 as=4.1e-13 pd=2.64e-06 ps=2.64e-06
X_i_0_1 ZN A1 net_0_0 VPW nfet_05v0 W=8.2e-07 L=6e-07 ad=4.1e-13 as=4.1e-13 pd=2.64e-06 ps=2.64e-06
X_i_0_0 net_0_1 A1 ZN VPW nfet_05v0 W=8.2e-07 L=6e-07 ad=4.1e-13 as=4.1e-13 pd=2.64e-06 ps=2.64e-06
X_i_1_0 VSS A2 net_0_1 VPW nfet_05v0 W=8.2e-07 L=6e-07 ad=4.1e-13 as=4.1e-13 pd=2.64e-06 ps=2.64e-06
X_i_3_1 ZN A2 VDD VNW pfet_05v0 W=1.13e-06 L=5e-07 ad=5.65e-13 as=5.65e-13 pd=3.26e-06 ps=3.26e-06
X_i_2_1 VDD A1 ZN VNW pfet_05v0 W=1.13e-06 L=5e-07 ad=5.65e-13 as=5.65e-13 pd=3.26e-06 ps=3.26e-06
X_i_2_0 ZN A1 VDD VNW pfet_05v0 W=1.13e-06 L=5e-07 ad=5.65e-13 as=5.65e-13 pd=3.26e-06 ps=3.26e-06
X_i_3_0 VDD A2 ZN VNW pfet_05v0 W=1.13e-06 L=5e-07 ad=5.65e-13 as=5.65e-13 pd=3.26e-06 ps=3.26e-06
.ENDS
.SUBCKT gf180mcu_fd_sc_mcu7t5v0__nand2_4 A1 A2 ZN VDD VNW VPW VSS
X_i_1_3 net_0_0 A2 VSS VPW nfet_05v0 W=8.2e-07 L=6e-07 ad=4.1e-13 as=4.1e-13 pd=2.64e-06 ps=2.64e-06
X_i_0_3 ZN A1 net_0_0 VPW nfet_05v0 W=8.2e-07 L=6e-07 ad=4.1e-13 as=4.1e-13 pd=2.64e-06 ps=2.64e-06
X_i_0_2 net_0_1 A1 ZN VPW nfet_05v0 W=8.2e-07 L=6e-07 ad=4.1e-13 as=4.1e-13 pd=2.64e-06 ps=2.64e-06
X_i_1_2 VSS A2 net_0_1 VPW nfet_05v0 W=8.2e-07 L=6e-07 ad=4.1e-13 as=4.1e-13 pd=2.64e-06 ps=2.64e-06
X_i_1_1 net_0_2 A2 VSS VPW nfet_05v0 W=8.2e-07 L=6e-07 ad=4.1e-13 as=4.1e-13 pd=2.64e-06 ps=2.64e-06
X_i_0_1 ZN A1 net_0_2 VPW nfet_05v0 W=8.2e-07 L=6e-07 ad=4.1e-13 as=4.1e-13 pd=2.64e-06 ps=2.64e-06
X_i_0_0 net_0_3 A1 ZN VPW nfet_05v0 W=8.2e-07 L=6e-07 ad=4.1e-13 as=4.1e-13 pd=2.64e-06 ps=2.64e-06
X_i_1_0 VSS A2 net_0_3 VPW nfet_05v0 W=8.2e-07 L=6e-07 ad=4.1e-13 as=4.1e-13 pd=2.64e-06 ps=2.64e-06
X_i_3_3 ZN A2 VDD VNW pfet_05v0 W=1.13e-06 L=5e-07 ad=5.65e-13 as=5.65e-13 pd=3.26e-06 ps=3.26e-06
X_i_2_3 VDD A1 ZN VNW pfet_05v0 W=1.13e-06 L=5e-07 ad=5.65e-13 as=5.65e-13 pd=3.26e-06 ps=3.26e-06
X_i_2_2 ZN A1 VDD VNW pfet_05v0 W=1.13e-06 L=5e-07 ad=5.65e-13 as=5.65e-13 pd=3.26e-06 ps=3.26e-06
X_i_3_2 VDD A2 ZN VNW pfet_05v0 W=1.13e-06 L=5e-07 ad=5.65e-13 as=5.65e-13 pd=3.26e-06 ps=3.26e-06
X_i_3_1 ZN A2 VDD VNW pfet_05v0 W=1.13e-06 L=5e-07 ad=5.65e-13 as=5.65e-13 pd=3.26e-06 ps=3.26e-06
X_i_2_1 VDD A1 ZN VNW pfet_05v0 W=1.13e-06 L=5e-07 ad=5.65e-13 as=5.65e-13 pd=3.26e-06 ps=3.26e-06
X_i_2_0 ZN A1 VDD VNW pfet_05v0 W=1.13e-06 L=5e-07 ad=5.65e-13 as=5.65e-13 pd=3.26e-06 ps=3.26e-06
X_i_3_0 VDD A2 ZN VNW pfet_05v0 W=1.13e-06 L=5e-07 ad=5.65e-13 as=5.65e-13 pd=3.26e-06 ps=3.26e-06
.ENDS
.SUBCKT gf180mcu_fd_sc_mcu7t5v0__or2_1 A1 A2 Z VDD VNW VPW VSS
X_i_2 Z_neg A1 VSS VPW nfet_05v0 W=3.6e-07 L=6e-07 ad=1.8e-13 as=1.8e-13 pd=1.72e-06 ps=1.72e-06
X_i_3 VSS A2 Z_neg VPW nfet_05v0 W=3.6e-07 L=6e-07 ad=1.8e-13 as=1.8e-13 pd=1.72e-06 ps=1.72e-06
X_i_0 Z Z_neg VSS VPW nfet_05v0 W=8.2e-07 L=6e-07 ad=4.1e-13 as=4.1e-13 pd=2.64e-06 ps=2.64e-06
X_i_4 net_0 A1 Z_neg VNW pfet_05v0 W=5.65e-07 L=5e-07 ad=2.825e-13 as=2.825e-13 pd=2.13e-06 ps=2.13e-06
X_i_5 VDD A2 net_0 VNW pfet_05v0 W=5.65e-07 L=5e-07 ad=2.825e-13 as=2.825e-13 pd=2.13e-06 ps=2.13e-06
X_i_1 Z Z_neg VDD VNW pfet_05v0 W=1.22e-06 L=5e-07 ad=6.1e-13 as=6.1e-13 pd=3.44e-06 ps=3.44e-06
.ENDS
.SUBCKT gf180mcu_fd_sc_mcu7t5v0__tiel ZN VDD VNW VPW VSS
X_n_tran_1 VSS A ZN VPW nfet_05v0 W=8.2e-07 L=6e-07 ad=4.1e-13 as=4.1e-13 pd=2.64e-06 ps=2.64e-06
X_transistor_0 VDD A A VNW pfet_05v0 W=1.22e-06 L=5e-07 ad=6.1e-13 as=6.1e-13 pd=3.44e-06 ps=3.44e-06
.ENDS
.SUBCKT gf180mcu_fd_sc_mcu7t5v0__xor2_1 A1 A2 Z VDD VNW VPW VSS
X_i_6 I A2 VSS VPW nfet_05v0 W=3.6e-07 L=6e-07 ad=1.8e-13 as=1.8e-13 pd=1.72e-06 ps=1.72e-06
X_i_7 VSS A1 I VPW nfet_05v0 W=3.6e-07 L=6e-07 ad=1.8e-13 as=1.8e-13 pd=1.72e-06 ps=1.72e-06
X_i_2 Z I VSS VPW nfet_05v0 W=8.2e-07 L=6e-07 ad=4.1e-13 as=4.1e-13 pd=2.64e-06 ps=2.64e-06
X_i_0 net_0 A1 Z VPW nfet_05v0 W=8.2e-07 L=6e-07 ad=4.1e-13 as=4.1e-13 pd=2.64e-06 ps=2.64e-06
X_i_1 VSS A2 net_0 VPW nfet_05v0 W=8.2e-07 L=6e-07 ad=4.1e-13 as=4.1e-13 pd=2.64e-06 ps=2.64e-06
X_i_8 net_2 A2 I VNW pfet_05v0 W=5.6e-07 L=5e-07 ad=2.8e-13 as=2.8e-13 pd=2.12e-06 ps=2.12e-06
X_i_9 VDD A1 net_2 VNW pfet_05v0 W=5.6e-07 L=5e-07 ad=2.8e-13 as=2.8e-13 pd=2.12e-06 ps=2.12e-06
X_i_5 net_1 I VDD VNW pfet_05v0 W=1.22e-06 L=5e-07 ad=6.1e-13 as=6.1e-13 pd=3.44e-06 ps=3.44e-06
X_i_3 Z A1 net_1 VNW pfet_05v0 W=1.22e-06 L=5e-07 ad=6.1e-13 as=6.1e-13 pd=3.44e-06 ps=3.44e-06
X_i_4 net_1 A2 Z VNW pfet_05v0 W=1.22e-06 L=5e-07 ad=6.1e-13 as=6.1e-13 pd=3.44e-06 ps=3.44e-06
.ENDS

.SUBCKT meta_dut_baseline d clk q VDPWR VGND
Xu_cki clk clkn VDPWR VDPWR VGND VGND gf180mcu_fd_sc_mcu7t5v0__inv_1
Xu_mg1 d clkn g1 VDPWR VDPWR VGND VGND gf180mcu_fd_sc_mcu7t5v0__nand2_1
Xu_mg2 g1 clkn g2 VDPWR VDPWR VGND VGND gf180mcu_fd_sc_mcu7t5v0__nand2_1
Xu_mfw mqb g1 mq VDPWR VDPWR VGND VGND gf180mcu_fd_sc_mcu7t5v0__nand2_2
Xu_mkp mq g2 mqb VDPWR VDPWR VGND VGND gf180mcu_fd_sc_mcu7t5v0__nand2_1
Xu_sg1 mq clk s1 VDPWR VDPWR VGND VGND gf180mcu_fd_sc_mcu7t5v0__nand2_1
Xu_sg2 s1 clk s2 VDPWR VDPWR VGND VGND gf180mcu_fd_sc_mcu7t5v0__nand2_1
Xu_sfw sqb s1 q VDPWR VDPWR VGND VGND gf180mcu_fd_sc_mcu7t5v0__nand2_1
Xu_skp q s2 sqb VDPWR VDPWR VGND VGND gf180mcu_fd_sc_mcu7t5v0__nand2_1
.ENDS

.SUBCKT meta_dut_keeper d clk q VDPWR VGND
Xu_cki clk clkn VDPWR VDPWR VGND VGND gf180mcu_fd_sc_mcu7t5v0__inv_1
Xu_mg1 d clkn g1 VDPWR VDPWR VGND VGND gf180mcu_fd_sc_mcu7t5v0__nand2_1
Xu_mg2 g1 clkn g2 VDPWR VDPWR VGND VGND gf180mcu_fd_sc_mcu7t5v0__nand2_1
Xu_mfw mqb g1 mq VDPWR VDPWR VGND VGND gf180mcu_fd_sc_mcu7t5v0__nand2_2
Xu_mkp mq g2 mqb VDPWR VDPWR VGND VGND gf180mcu_fd_sc_mcu7t5v0__nand2_2
Xu_sg1 mq clk s1 VDPWR VDPWR VGND VGND gf180mcu_fd_sc_mcu7t5v0__nand2_1
Xu_sg2 s1 clk s2 VDPWR VDPWR VGND VGND gf180mcu_fd_sc_mcu7t5v0__nand2_1
Xu_sfw sqb s1 q VDPWR VDPWR VGND VGND gf180mcu_fd_sc_mcu7t5v0__nand2_1
Xu_skp q s2 sqb VDPWR VDPWR VGND VGND gf180mcu_fd_sc_mcu7t5v0__nand2_1
.ENDS

.SUBCKT meta_dut_forward d clk q VDPWR VGND
Xu_cki clk clkn VDPWR VDPWR VGND VGND gf180mcu_fd_sc_mcu7t5v0__inv_1
Xu_mg1 d clkn g1 VDPWR VDPWR VGND VGND gf180mcu_fd_sc_mcu7t5v0__nand2_1
Xu_mg2 g1 clkn g2 VDPWR VDPWR VGND VGND gf180mcu_fd_sc_mcu7t5v0__nand2_1
Xu_mfw mqb g1 mq VDPWR VDPWR VGND VGND gf180mcu_fd_sc_mcu7t5v0__nand2_4
Xu_mkp mq g2 mqb VDPWR VDPWR VGND VGND gf180mcu_fd_sc_mcu7t5v0__nand2_1
Xu_sg1 mq clk s1 VDPWR VDPWR VGND VGND gf180mcu_fd_sc_mcu7t5v0__nand2_1
Xu_sg2 s1 clk s2 VDPWR VDPWR VGND VGND gf180mcu_fd_sc_mcu7t5v0__nand2_1
Xu_sfw sqb s1 q VDPWR VDPWR VGND VGND gf180mcu_fd_sc_mcu7t5v0__nand2_1
Xu_skp q s2 sqb VDPWR VDPWR VGND VGND gf180mcu_fd_sc_mcu7t5v0__nand2_1
.ENDS

.SUBCKT meta_delay_analog launch control sample_clk VDPWR VGND
XMMP slow launch VDPWR VDPWR pfet_05v0 w=1.22e-06 l=5e-07 ad=6.1e-13 as=6.1e-13 pd=3.44e-06 ps=3.44e-06
XMMN slow launch foot VGND nfet_05v0 w=8.2e-07 l=6e-07 ad=4.1e-13 as=4.1e-13 pd=2.64e-06 ps=2.64e-06
XMMC foot control VGND VGND nfet_05v0 w=3.6e-07 l=6e-07 ad=1.8e-13 as=1.8e-13 pd=1.72e-06 ps=1.72e-06
XMMCT VGND slow VGND VGND nfet_06v0 w=8.2e-07 l=1e-06 ad=4.1e-13 as=4.1e-13 pd=2.64e-06 ps=2.64e-06
XXR0 slow r0 VDPWR VDPWR VGND VGND gf180mcu_fd_sc_mcu7t5v0__inv_1
XXR1 r0 r1 VDPWR VDPWR VGND VGND gf180mcu_fd_sc_mcu7t5v0__inv_2
XXR2 r1 sample_clk VDPWR VDPWR VGND VGND gf180mcu_fd_sc_mcu7t5v0__inv_2
.ENDS

.SUBCKT compact_control clk20 rst_n ena start q_selected early_e byte_sel capture busy done fault result_byte[0] result_byte[1] result_byte[2] result_byte[3] result_byte[4] result_byte[5] result_byte[6] result_byte[7] VDPWR VGND
Xa_ff b clk20 capture VDPWR VDPWR VGND VGND gf180mcu_fd_sc_mcu7t5v0__dffq_1
Xa_inv capture a_n VDPWR VDPWR VGND VGND gf180mcu_fd_sc_mcu7t5v0__inv_1
Xallow_ff want_count rst_n b allow_count VDPWR VDPWR VGND VGND gf180mcu_fd_sc_mcu7t5v0__dffnrnq_1
Xb_ff a_n rst_n clk20 b VDPWR VDPWR VGND VGND gf180mcu_fd_sc_mcu7t5v0__dffrnq_1
Xbad_xor l1 l2 bad_bit VDPWR VDPWR VGND VGND gf180mcu_fd_sc_mcu7t5v0__xor2_1
Xbusy_and run done_n busy VDPWR VDPWR VGND VGND gf180mcu_fd_sc_mcu7t5v0__and2_1
Xdone_ff n[16] run b done VDPWR VDPWR VGND VGND gf180mcu_fd_sc_mcu7t5v0__dffnrnq_1
Xdone_inv done done_n VDPWR VDPWR VGND VGND gf180mcu_fd_sc_mcu7t5v0__inv_1
Xevent_xor early_e l2 event_bit VDPWR VDPWR VGND VGND gf180mcu_fd_sc_mcu7t5v0__xor2_1
Xfault_ff fault_d run tick_n fault VDPWR VDPWR VGND VGND gf180mcu_fd_sc_mcu7t5v0__dffnrnq_1
Xfault_or fault bad_bit fault_d VDPWR VDPWR VGND VGND gf180mcu_fd_sc_mcu7t5v0__or2_1
Xfinished_inv n[16] finished_n VDPWR VDPWR VGND VGND gf180mcu_fd_sc_mcu7t5v0__inv_1
Xbyte0_mux k[0] k[8] byte_sel result_byte[0] VDPWR VDPWR VGND VGND gf180mcu_fd_sc_mcu7t5v0__mux2_1
Xbyte1_mux k[1] k[9] byte_sel result_byte[1] VDPWR VDPWR VGND VGND gf180mcu_fd_sc_mcu7t5v0__mux2_1
Xbyte2_mux k[2] k[10] byte_sel result_byte[2] VDPWR VDPWR VGND VGND gf180mcu_fd_sc_mcu7t5v0__mux2_1
Xbyte3_mux k[3] k[11] byte_sel result_byte[3] VDPWR VDPWR VGND VGND gf180mcu_fd_sc_mcu7t5v0__mux2_1
Xbyte4_mux k[4] k[12] byte_sel result_byte[4] VDPWR VDPWR VGND VGND gf180mcu_fd_sc_mcu7t5v0__mux2_1
Xbyte5_mux k[5] k[13] byte_sel result_byte[5] VDPWR VDPWR VGND VGND gf180mcu_fd_sc_mcu7t5v0__mux2_1
Xbyte6_mux k[6] k[14] byte_sel result_byte[6] VDPWR VDPWR VGND VGND gf180mcu_fd_sc_mcu7t5v0__mux2_1
Xbyte7_mux k[7] k[15] byte_sel result_byte[7] VDPWR VDPWR VGND VGND gf180mcu_fd_sc_mcu7t5v0__mux2_1
Xk10_ff k_n[10] run k[9] k[10] VDPWR VDPWR VGND VGND gf180mcu_fd_sc_mcu7t5v0__dffnrnq_1
Xk10_inv k[10] k_n[10] VDPWR VDPWR VGND VGND gf180mcu_fd_sc_mcu7t5v0__inv_1
Xk11_ff k_n[11] run k[10] k[11] VDPWR VDPWR VGND VGND gf180mcu_fd_sc_mcu7t5v0__dffnrnq_1
Xk11_inv k[11] k_n[11] VDPWR VDPWR VGND VGND gf180mcu_fd_sc_mcu7t5v0__inv_1
Xk12_ff k_n[12] run k[11] k[12] VDPWR VDPWR VGND VGND gf180mcu_fd_sc_mcu7t5v0__dffnrnq_1
Xk12_inv k[12] k_n[12] VDPWR VDPWR VGND VGND gf180mcu_fd_sc_mcu7t5v0__inv_1
Xk13_ff k_n[13] run k[12] k[13] VDPWR VDPWR VGND VGND gf180mcu_fd_sc_mcu7t5v0__dffnrnq_1
Xk13_inv k[13] k_n[13] VDPWR VDPWR VGND VGND gf180mcu_fd_sc_mcu7t5v0__inv_1
Xk14_ff k_n[14] run k[13] k[14] VDPWR VDPWR VGND VGND gf180mcu_fd_sc_mcu7t5v0__dffnrnq_1
Xk14_inv k[14] k_n[14] VDPWR VDPWR VGND VGND gf180mcu_fd_sc_mcu7t5v0__inv_1
Xk15_ff k_n[15] run k[14] k[15] VDPWR VDPWR VGND VGND gf180mcu_fd_sc_mcu7t5v0__dffnrnq_1
Xk15_inv k[15] k_n[15] VDPWR VDPWR VGND VGND gf180mcu_fd_sc_mcu7t5v0__inv_1
Xk1_ff k_n[1] run k[0] k[1] VDPWR VDPWR VGND VGND gf180mcu_fd_sc_mcu7t5v0__dffnrnq_1
Xk1_inv k[1] k_n[1] VDPWR VDPWR VGND VGND gf180mcu_fd_sc_mcu7t5v0__inv_1
Xk2_ff k_n[2] run k[1] k[2] VDPWR VDPWR VGND VGND gf180mcu_fd_sc_mcu7t5v0__dffnrnq_1
Xk2_inv k[2] k_n[2] VDPWR VDPWR VGND VGND gf180mcu_fd_sc_mcu7t5v0__inv_1
Xk3_ff k_n[3] run k[2] k[3] VDPWR VDPWR VGND VGND gf180mcu_fd_sc_mcu7t5v0__dffnrnq_1
Xk3_inv k[3] k_n[3] VDPWR VDPWR VGND VGND gf180mcu_fd_sc_mcu7t5v0__inv_1
Xk4_ff k_n[4] run k[3] k[4] VDPWR VDPWR VGND VGND gf180mcu_fd_sc_mcu7t5v0__dffnrnq_1
Xk4_inv k[4] k_n[4] VDPWR VDPWR VGND VGND gf180mcu_fd_sc_mcu7t5v0__inv_1
Xk5_ff k_n[5] run k[4] k[5] VDPWR VDPWR VGND VGND gf180mcu_fd_sc_mcu7t5v0__dffnrnq_1
Xk5_inv k[5] k_n[5] VDPWR VDPWR VGND VGND gf180mcu_fd_sc_mcu7t5v0__inv_1
Xk6_ff k_n[6] run k[5] k[6] VDPWR VDPWR VGND VGND gf180mcu_fd_sc_mcu7t5v0__dffnrnq_1
Xk6_inv k[6] k_n[6] VDPWR VDPWR VGND VGND gf180mcu_fd_sc_mcu7t5v0__inv_1
Xk7_ff k_n[7] run k[6] k[7] VDPWR VDPWR VGND VGND gf180mcu_fd_sc_mcu7t5v0__dffnrnq_1
Xk7_inv k[7] k_n[7] VDPWR VDPWR VGND VGND gf180mcu_fd_sc_mcu7t5v0__inv_1
Xk8_ff k_n[8] run k[7] k[8] VDPWR VDPWR VGND VGND gf180mcu_fd_sc_mcu7t5v0__dffnrnq_1
Xk8_inv k[8] k_n[8] VDPWR VDPWR VGND VGND gf180mcu_fd_sc_mcu7t5v0__inv_1
Xk9_ff k_n[9] run k[8] k[9] VDPWR VDPWR VGND VGND gf180mcu_fd_sc_mcu7t5v0__dffnrnq_1
Xk9_inv k[9] k_n[9] VDPWR VDPWR VGND VGND gf180mcu_fd_sc_mcu7t5v0__inv_1
Xn0_ff n_n[0] run tick_n n[0] VDPWR VDPWR VGND VGND gf180mcu_fd_sc_mcu7t5v0__dffnrnq_1
Xn0_inv n[0] n_n[0] VDPWR VDPWR VGND VGND gf180mcu_fd_sc_mcu7t5v0__inv_1
Xn10_ff n_n[10] run n[9] n[10] VDPWR VDPWR VGND VGND gf180mcu_fd_sc_mcu7t5v0__dffnrnq_1
Xn10_inv n[10] n_n[10] VDPWR VDPWR VGND VGND gf180mcu_fd_sc_mcu7t5v0__inv_1
Xn11_ff n_n[11] run n[10] n[11] VDPWR VDPWR VGND VGND gf180mcu_fd_sc_mcu7t5v0__dffnrnq_1
Xn11_inv n[11] n_n[11] VDPWR VDPWR VGND VGND gf180mcu_fd_sc_mcu7t5v0__inv_1
Xn12_ff n_n[12] run n[11] n[12] VDPWR VDPWR VGND VGND gf180mcu_fd_sc_mcu7t5v0__dffnrnq_1
Xn12_inv n[12] n_n[12] VDPWR VDPWR VGND VGND gf180mcu_fd_sc_mcu7t5v0__inv_1
Xn13_ff n_n[13] run n[12] n[13] VDPWR VDPWR VGND VGND gf180mcu_fd_sc_mcu7t5v0__dffnrnq_1
Xn13_inv n[13] n_n[13] VDPWR VDPWR VGND VGND gf180mcu_fd_sc_mcu7t5v0__inv_1
Xn14_ff n_n[14] run n[13] n[14] VDPWR VDPWR VGND VGND gf180mcu_fd_sc_mcu7t5v0__dffnrnq_1
Xn14_inv n[14] n_n[14] VDPWR VDPWR VGND VGND gf180mcu_fd_sc_mcu7t5v0__inv_1
Xn15_ff n_n[15] run n[14] n[15] VDPWR VDPWR VGND VGND gf180mcu_fd_sc_mcu7t5v0__dffnrnq_1
Xn15_inv n[15] n_n[15] VDPWR VDPWR VGND VGND gf180mcu_fd_sc_mcu7t5v0__inv_1
Xn16_ff n_n[16] run n[15] n[16] VDPWR VDPWR VGND VGND gf180mcu_fd_sc_mcu7t5v0__dffnrnq_1
Xn16_inv n[16] n_n[16] VDPWR VDPWR VGND VGND gf180mcu_fd_sc_mcu7t5v0__inv_1
Xn1_ff n_n[1] run n_n[0] n[1] VDPWR VDPWR VGND VGND gf180mcu_fd_sc_mcu7t5v0__dffnrnq_1
Xn1_inv n[1] n_n[1] VDPWR VDPWR VGND VGND gf180mcu_fd_sc_mcu7t5v0__inv_1
Xn2_ff n_n[2] run n[1] n[2] VDPWR VDPWR VGND VGND gf180mcu_fd_sc_mcu7t5v0__dffnrnq_1
Xn2_inv n[2] n_n[2] VDPWR VDPWR VGND VGND gf180mcu_fd_sc_mcu7t5v0__inv_1
Xn3_ff n_n[3] run n[2] n[3] VDPWR VDPWR VGND VGND gf180mcu_fd_sc_mcu7t5v0__dffnrnq_1
Xn3_inv n[3] n_n[3] VDPWR VDPWR VGND VGND gf180mcu_fd_sc_mcu7t5v0__inv_1
Xn4_ff n_n[4] run n[3] n[4] VDPWR VDPWR VGND VGND gf180mcu_fd_sc_mcu7t5v0__dffnrnq_1
Xn4_inv n[4] n_n[4] VDPWR VDPWR VGND VGND gf180mcu_fd_sc_mcu7t5v0__inv_1
Xn5_ff n_n[5] run n[4] n[5] VDPWR VDPWR VGND VGND gf180mcu_fd_sc_mcu7t5v0__dffnrnq_1
Xn5_inv n[5] n_n[5] VDPWR VDPWR VGND VGND gf180mcu_fd_sc_mcu7t5v0__inv_1
Xn6_ff n_n[6] run n[5] n[6] VDPWR VDPWR VGND VGND gf180mcu_fd_sc_mcu7t5v0__dffnrnq_1
Xn6_inv n[6] n_n[6] VDPWR VDPWR VGND VGND gf180mcu_fd_sc_mcu7t5v0__inv_1
Xn7_ff n_n[7] run n[6] n[7] VDPWR VDPWR VGND VGND gf180mcu_fd_sc_mcu7t5v0__dffnrnq_1
Xn7_inv n[7] n_n[7] VDPWR VDPWR VGND VGND gf180mcu_fd_sc_mcu7t5v0__inv_1
Xn8_ff n_n[8] run n[7] n[8] VDPWR VDPWR VGND VGND gf180mcu_fd_sc_mcu7t5v0__dffnrnq_1
Xn8_inv n[8] n_n[8] VDPWR VDPWR VGND VGND gf180mcu_fd_sc_mcu7t5v0__inv_1
Xn9_ff n_n[9] run n[8] n[9] VDPWR VDPWR VGND VGND gf180mcu_fd_sc_mcu7t5v0__dffnrnq_1
Xn9_inv n[9] n_n[9] VDPWR VDPWR VGND VGND gf180mcu_fd_sc_mcu7t5v0__inv_1
Xk0_ff k0_d run tick_n k[0] VDPWR VDPWR VGND VGND gf180mcu_fd_sc_mcu7t5v0__dffnrnq_1
Xk0_xor k[0] event_bit k0_d VDPWR VDPWR VGND VGND gf180mcu_fd_sc_mcu7t5v0__xor2_1
Xl1_ff q_selected b l1 VDPWR VDPWR VGND VGND gf180mcu_fd_sc_mcu7t5v0__dffnq_1
Xl2_ff q_selected a_n l2 VDPWR VDPWR VGND VGND gf180mcu_fd_sc_mcu7t5v0__dffq_1
Xrequest_and ena start request VDPWR VDPWR VGND VGND gf180mcu_fd_sc_mcu7t5v0__and2_1
Xrun_ff start_meta rst_n a_n run VDPWR VDPWR VGND VGND gf180mcu_fd_sc_mcu7t5v0__dffrnq_1
Xstart_meta_ff request rst_n a_n start_meta VDPWR VDPWR VGND VGND gf180mcu_fd_sc_mcu7t5v0__dffrnq_1
Xtick_nand b allow_count tick_n VDPWR VDPWR VGND VGND gf180mcu_fd_sc_mcu7t5v0__nand2_1
Xwant_and run finished_n want_count VDPWR VDPWR VGND VGND gf180mcu_fd_sc_mcu7t5v0__and2_1
.ENDS

.SUBCKT tt_um_metastability_characterizer VDPWR VGND ui_in[0] ui_in[1] ui_in[2] ui_in[3] ui_in[4] ui_in[5] ui_in[6] ui_in[7] uo_out[0] uo_out[1] uo_out[2] uo_out[3] uo_out[4] uo_out[5] uo_out[6] uo_out[7] uio_in[0] uio_in[1] uio_in[2] uio_in[3] uio_in[4] uio_in[5] uio_in[6] uio_in[7] uio_out[0] uio_out[1] uio_out[2] uio_out[3] uio_out[4] uio_out[5] uio_out[6] uio_out[7] uio_oe[0] uio_oe[1] uio_oe[2] uio_oe[3] uio_oe[4] uio_oe[5] uio_oe[6] uio_oe[7] ua[0] ua[1] ua[2] ua[3] ua[4] ua[5] ua[6] ua[7] ena clk rst_n
Xcontroller clk rst_n ena ui_in[4] selected_q early_q ui_in[0] capture uio_out[1] uio_out[2] uio_out[3] uo_out[0] uo_out[1] uo_out[2] uo_out[3] uo_out[4] uo_out[5] uo_out[6] uo_out[7] VDPWR VGND compact_control
Xdata0 ui_in[6] data_b VDPWR VDPWR VGND VGND gf180mcu_fd_sc_mcu7t5v0__inv_2
Xdata1 data_b data_local VDPWR VDPWR VGND VGND gf180mcu_fd_sc_mcu7t5v0__inv_2
Xcap0 capture capture_b VDPWR VDPWR VGND VGND gf180mcu_fd_sc_mcu7t5v0__inv_2
Xcap1 capture_b capture_local VDPWR VDPWR VGND VGND gf180mcu_fd_sc_mcu7t5v0__inv_2
Xu_dut1 data_local capture_local q[0] VDPWR VDPWR VGND VGND gf180mcu_fd_sc_mcu7t5v0__dffq_1
Xselect_dut q[0] q[1] q[2] q[3] ui_in[3] uio_in[6] selected_q VDPWR VDPWR VGND VGND gf180mcu_fd_sc_mcu7t5v0__mux4_1
Xiso0 capture_local capture_iso_b VDPWR VDPWR VGND VGND gf180mcu_fd_sc_mcu7t5v0__inv_1
Xiso1 capture_iso_b capture_iso VDPWR VDPWR VGND VGND gf180mcu_fd_sc_mcu7t5v0__inv_2
Xant_ctrl ua[0] VDPWR VDPWR VGND VGND gf180mcu_fd_sc_mcu7t5v0__antenna
Xearly_observer selected_q early_clk early_q VDPWR VDPWR VGND VGND gf180mcu_fd_sc_mcu7t5v0__dffq_1
Xmonitor_capture_a capture_local capmon_n VDPWR VDPWR VGND VGND gf180mcu_fd_sc_mcu7t5v0__inv_1
Xmonitor_capture_b capmon_n uio_out[4] VDPWR VDPWR VGND VGND gf180mcu_fd_sc_mcu7t5v0__inv_2
Xmonitor_early_a early_clk earlymon_n VDPWR VDPWR VGND VGND gf180mcu_fd_sc_mcu7t5v0__inv_1
Xmonitor_early_b earlymon_n uio_out[5] VDPWR VDPWR VGND VGND gf180mcu_fd_sc_mcu7t5v0__inv_2
Xoe_buf1 ena uio_oe[1] VDPWR VDPWR VGND VGND gf180mcu_fd_sc_mcu7t5v0__buf_1
Xoe_buf2 ena uio_oe[2] VDPWR VDPWR VGND VGND gf180mcu_fd_sc_mcu7t5v0__buf_1
Xoe_buf3 ena uio_oe[3] VDPWR VDPWR VGND VGND gf180mcu_fd_sc_mcu7t5v0__buf_1
Xoe_buf4 ena uio_oe[4] VDPWR VDPWR VGND VGND gf180mcu_fd_sc_mcu7t5v0__buf_1
Xoe_buf5 ena uio_oe[5] VDPWR VDPWR VGND VGND gf180mcu_fd_sc_mcu7t5v0__buf_1
Xtielo_uio_oe0 uio_oe[0] VDPWR VDPWR VGND VGND gf180mcu_fd_sc_mcu7t5v0__tiel
Xtielo_uio_oe6 uio_oe[6] VDPWR VDPWR VGND VGND gf180mcu_fd_sc_mcu7t5v0__tiel
Xtielo_uio_oe7 uio_oe[7] VDPWR VDPWR VGND VGND gf180mcu_fd_sc_mcu7t5v0__tiel
Xtielo_uio_out0 uio_out[0] VDPWR VDPWR VGND VGND gf180mcu_fd_sc_mcu7t5v0__tiel
Xtielo_uio_out6 uio_out[6] VDPWR VDPWR VGND VGND gf180mcu_fd_sc_mcu7t5v0__tiel
Xtielo_uio_out7 uio_out[7] VDPWR VDPWR VGND VGND gf180mcu_fd_sc_mcu7t5v0__tiel
Xu_dut2 data_local capture_local q[1] VDPWR VGND meta_dut_baseline
Xu_dut3 data_local capture_local q[2] VDPWR VGND meta_dut_keeper
Xu_dut4 data_local capture_local q[3] VDPWR VGND meta_dut_forward
Xdelay capture_iso ua[0] early_clk VDPWR VGND meta_delay_analog
.ENDS
